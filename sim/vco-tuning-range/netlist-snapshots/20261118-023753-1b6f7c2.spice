* Frozen netlist snapshot for record 20261118-023753-1b6f7c2
* sources    : vco.spice + tb_vco_pushing.spice + tb_vco_supply_jitter.spice (composed at record time, in this order)
* sha256     : 281fef668642181ab724b0c862ac98420298bd4f0b3d78076c2d6aa82a19b586 (of this composed text)
* This is a verbatim composition taken at record time. Do not edit.

* ---- design/netlist/vco.spice (sha256 3d8bf1b307d7b230808c86b318262822fdf525c2503724609bdf51d1b1cc2d31)
* gf180-pll :: VCO netlist exported from design/vco.sch by design/netlist.sh
* Do not edit by hand -- edit the schematics and re-run design/netlist.sh.
** sch_path: design/vco.sch
.subckt vco VCTRL B0 B1 B2 CLK VDD_VCO GND_VCO
*.ipin VCTRL
*.ipin B0
*.ipin B1
*.ipin B2
*.opin CLK
*.iopin VDD_VCO
*.iopin GND_VCO
XBIAS VCTRL B0 B1 B2 VBP VBN VDD_VCO GND_VCO vco_bias
XS1 Y5 Y1 VDD_VCO GND_VCO VBP VBN vco_stage
XS2 Y1 Y2 VDD_VCO GND_VCO VBP VBN vco_stage
XS3 Y2 Y3 VDD_VCO GND_VCO VBP VBN vco_stage
XS4 Y3 Y4 VDD_VCO GND_VCO VBP VBN vco_stage
XS5 Y4 Y5 VDD_VCO GND_VCO VBP VBN vco_stage
XMBP1 NB1 Y5 VDD_VCO VDD_VCO pfet_03v3 L=0.28u W=1.25u nf=1 ad='int((nf+1)/2) * W/nf * 0.18u' as='int((nf+2)/2) * W/nf * 0.18u' pd='2*int((nf+1)/2) * (W/nf + 0.18u)'
+ ps='2*int((nf+2)/2) * (W/nf + 0.18u)' nrd='0.18u / W' nrs='0.18u / W' sa=0 sb=0 sd=0 m=1
XMBN1 NB1 Y5 GND_VCO GND_VCO nfet_03v3 L=0.28u W=0.5u nf=1 ad='int((nf+1)/2) * W/nf * 0.18u' as='int((nf+2)/2) * W/nf * 0.18u' pd='2*int((nf+1)/2) * (W/nf + 0.18u)'
+ ps='2*int((nf+2)/2) * (W/nf + 0.18u)' nrd='0.18u / W' nrs='0.18u / W' sa=0 sb=0 sd=0 m=1
XMBP2 NB2 NB1 VDD_VCO VDD_VCO pfet_03v3 L=0.28u W=3.75u nf=1 ad='int((nf+1)/2) * W/nf * 0.18u' as='int((nf+2)/2) * W/nf * 0.18u' pd='2*int((nf+1)/2) * (W/nf + 0.18u)'
+ ps='2*int((nf+2)/2) * (W/nf + 0.18u)' nrd='0.18u / W' nrs='0.18u / W' sa=0 sb=0 sd=0 m=1
XMBN2 NB2 NB1 GND_VCO GND_VCO nfet_03v3 L=0.28u W=1.5u nf=1 ad='int((nf+1)/2) * W/nf * 0.18u' as='int((nf+2)/2) * W/nf * 0.18u' pd='2*int((nf+1)/2) * (W/nf + 0.18u)'
+ ps='2*int((nf+2)/2) * (W/nf + 0.18u)' nrd='0.18u / W' nrs='0.18u / W' sa=0 sb=0 sd=0 m=1
XMBP3 CLK NB2 VDD_VCO VDD_VCO pfet_03v3 L=0.28u W=11.25u nf=1 ad='int((nf+1)/2) * W/nf * 0.18u' as='int((nf+2)/2) * W/nf * 0.18u' pd='2*int((nf+1)/2) * (W/nf + 0.18u)'
+ ps='2*int((nf+2)/2) * (W/nf + 0.18u)' nrd='0.18u / W' nrs='0.18u / W' sa=0 sb=0 sd=0 m=1
XMBN3 CLK NB2 GND_VCO GND_VCO nfet_03v3 L=0.28u W=4.5u nf=1 ad='int((nf+1)/2) * W/nf * 0.18u' as='int((nf+2)/2) * W/nf * 0.18u' pd='2*int((nf+1)/2) * (W/nf + 0.18u)'
+ ps='2*int((nf+2)/2) * (W/nf + 0.18u)' nrd='0.18u / W' nrs='0.18u / W' sa=0 sb=0 sd=0 m=1
XCDEC1 VDD_VCO GND_VCO cap_nmos_03v3 c_width=50u c_length=50u m=1
XCDEC2 VDD_VCO GND_VCO cap_nmos_03v3 c_width=50u c_length=50u m=1
.ends

* expanding   symbol:  vco_bias.sym # of pins=8
** sym_path: design/vco_bias.sym
** sch_path: design/vco_bias.sch
.subckt vco_bias VCTRL B0 B1 B2 VBP VBN VDD VSS
*.ipin VCTRL
*.ipin B0
*.ipin B1
*.ipin B2
*.iopin VBP
*.iopin VBN
*.iopin VDD
*.iopin VSS
XMP1 NA VBPC VDD VDD pfet_03v3 L=1u W=10u nf=1 ad='int((nf+1)/2) * W/nf * 0.18u' as='int((nf+2)/2) * W/nf * 0.18u' pd='2*int((nf+1)/2) * (W/nf + 0.18u)'
+ ps='2*int((nf+2)/2) * (W/nf + 0.18u)' nrd='0.18u / W' nrs='0.18u / W' sa=0 sb=0 sd=0 m=1
XMP2 VBPC VBPC VDD VDD pfet_03v3 L=1u W=10u nf=1 ad='int((nf+1)/2) * W/nf * 0.18u' as='int((nf+2)/2) * W/nf * 0.18u' pd='2*int((nf+1)/2) * (W/nf + 0.18u)'
+ ps='2*int((nf+2)/2) * (W/nf + 0.18u)' nrd='0.18u / W' nrs='0.18u / W' sa=0 sb=0 sd=0 m=1
XMN1 NA NA VSS VSS nfet_03v3 L=1u W=1.4u nf=1 ad='int((nf+1)/2) * W/nf * 0.18u' as='int((nf+2)/2) * W/nf * 0.18u' pd='2*int((nf+1)/2) * (W/nf + 0.18u)'
+ ps='2*int((nf+2)/2) * (W/nf + 0.18u)' nrd='0.18u / W' nrs='0.18u / W' sa=0 sb=0 sd=0 m=1
XMN2 VBPC NA NC VSS nfet_03v3 L=1u W=5.6u nf=1 ad='int((nf+1)/2) * W/nf * 0.18u' as='int((nf+2)/2) * W/nf * 0.18u' pd='2*int((nf+1)/2) * (W/nf + 0.18u)'
+ ps='2*int((nf+2)/2) * (W/nf + 0.18u)' nrd='0.18u / W' nrs='0.18u / W' sa=0 sb=0 sd=0 m=1
XRCG NC VSS VSS ppolyf_u_3k r_width=1u r_length=5.6u m=1
XMSU1 NSU VSS VDD VDD pfet_03v3 L=20u W=0.22u nf=1 ad='int((nf+1)/2) * W/nf * 0.18u' as='int((nf+2)/2) * W/nf * 0.18u' pd='2*int((nf+1)/2) * (W/nf + 0.18u)'
+ ps='2*int((nf+2)/2) * (W/nf + 0.18u)' nrd='0.18u / W' nrs='0.18u / W' sa=0 sb=0 sd=0 m=1
XMSU2 NSU NA VSS VSS nfet_03v3 L=1u W=2u nf=1 ad='int((nf+1)/2) * W/nf * 0.18u' as='int((nf+2)/2) * W/nf * 0.18u' pd='2*int((nf+1)/2) * (W/nf + 0.18u)'
+ ps='2*int((nf+2)/2) * (W/nf + 0.18u)' nrd='0.18u / W' nrs='0.18u / W' sa=0 sb=0 sd=0 m=1
XMSU3 VBPC NSU VSS VSS nfet_03v3 L=1u W=1u nf=1 ad='int((nf+1)/2) * W/nf * 0.18u' as='int((nf+2)/2) * W/nf * 0.18u' pd='2*int((nf+1)/2) * (W/nf + 0.18u)'
+ ps='2*int((nf+2)/2) * (W/nf + 0.18u)' nrd='0.18u / W' nrs='0.18u / W' sa=0 sb=0 sd=0 m=1
XMPR VFIX VBPC VDD VDD pfet_03v3 L=1u W=2.5u nf=1 ad='int((nf+1)/2) * W/nf * 0.18u' as='int((nf+2)/2) * W/nf * 0.18u' pd='2*int((nf+1)/2) * (W/nf + 0.18u)'
+ ps='2*int((nf+2)/2) * (W/nf + 0.18u)' nrd='0.18u / W' nrs='0.18u / W' sa=0 sb=0 sd=0 m=1
XMD1 VFIX VFIX NMD VSS nfet_03v3 L=1u W=2u nf=1 ad='int((nf+1)/2) * W/nf * 0.18u' as='int((nf+2)/2) * W/nf * 0.18u' pd='2*int((nf+1)/2) * (W/nf + 0.18u)'
+ ps='2*int((nf+2)/2) * (W/nf + 0.18u)' nrd='0.18u / W' nrs='0.18u / W' sa=0 sb=0 sd=0 m=1
XMD2 NMD NMD VSS VSS nfet_03v3 L=1u W=2u nf=1 ad='int((nf+1)/2) * W/nf * 0.18u' as='int((nf+2)/2) * W/nf * 0.18u' pd='2*int((nf+1)/2) * (W/nf + 0.18u)'
+ ps='2*int((nf+2)/2) * (W/nf + 0.18u)' nrd='0.18u / W' nrs='0.18u / W' sa=0 sb=0 sd=0 m=1
XMOFF VBP0 VFIX NOFF VSS nfet_03v3 L=1u W=10u nf=1 ad='int((nf+1)/2) * W/nf * 0.18u' as='int((nf+2)/2) * W/nf * 0.18u' pd='2*int((nf+1)/2) * (W/nf + 0.18u)'
+ ps='2*int((nf+2)/2) * (W/nf + 0.18u)' nrd='0.18u / W' nrs='0.18u / W' sa=0 sb=0 sd=0 m=1
XROFF NOFF VSS VSS ppolyf_u_3k r_width=1u r_length=33u m=1
XMVI VBP0 VCTRL NVI VSS nfet_03v3 L=1u W=10u nf=1 ad='int((nf+1)/2) * W/nf * 0.18u' as='int((nf+2)/2) * W/nf * 0.18u' pd='2*int((nf+1)/2) * (W/nf + 0.18u)'
+ ps='2*int((nf+2)/2) * (W/nf + 0.18u)' nrd='0.18u / W' nrs='0.18u / W' sa=0 sb=0 sd=0 m=1
XRDEG NVI VSS VSS ppolyf_u_3k r_width=1u r_length=33u m=1
XMSUM VBP0 VBP0 VDD VDD pfet_03v3 L=1u W=60u nf=4 ad='int((nf+1)/2) * W/nf * 0.18u' as='int((nf+2)/2) * W/nf * 0.18u' pd='2*int((nf+1)/2) * (W/nf + 0.18u)'
+ ps='2*int((nf+2)/2) * (W/nf + 0.18u)' nrd='0.18u / W' nrs='0.18u / W' sa=0 sb=0 sd=0 m=1
XMIP0 B0B B0 VDD VDD pfet_03v3 L=0.28u W=2u nf=1 ad='int((nf+1)/2) * W/nf * 0.18u' as='int((nf+2)/2) * W/nf * 0.18u' pd='2*int((nf+1)/2) * (W/nf + 0.18u)'
+ ps='2*int((nf+2)/2) * (W/nf + 0.18u)' nrd='0.18u / W' nrs='0.18u / W' sa=0 sb=0 sd=0 m=1
XMIN0 B0B B0 VSS VSS nfet_03v3 L=0.28u W=1u nf=1 ad='int((nf+1)/2) * W/nf * 0.18u' as='int((nf+2)/2) * W/nf * 0.18u' pd='2*int((nf+1)/2) * (W/nf + 0.18u)'
+ ps='2*int((nf+2)/2) * (W/nf + 0.18u)' nrd='0.18u / W' nrs='0.18u / W' sa=0 sb=0 sd=0 m=1
XMIP1 B1B B1 VDD VDD pfet_03v3 L=0.28u W=2u nf=1 ad='int((nf+1)/2) * W/nf * 0.18u' as='int((nf+2)/2) * W/nf * 0.18u' pd='2*int((nf+1)/2) * (W/nf + 0.18u)'
+ ps='2*int((nf+2)/2) * (W/nf + 0.18u)' nrd='0.18u / W' nrs='0.18u / W' sa=0 sb=0 sd=0 m=1
XMIN1 B1B B1 VSS VSS nfet_03v3 L=0.28u W=1u nf=1 ad='int((nf+1)/2) * W/nf * 0.18u' as='int((nf+2)/2) * W/nf * 0.18u' pd='2*int((nf+1)/2) * (W/nf + 0.18u)'
+ ps='2*int((nf+2)/2) * (W/nf + 0.18u)' nrd='0.18u / W' nrs='0.18u / W' sa=0 sb=0 sd=0 m=1
XMIP2 B2B B2 VDD VDD pfet_03v3 L=0.28u W=2u nf=1 ad='int((nf+1)/2) * W/nf * 0.18u' as='int((nf+2)/2) * W/nf * 0.18u' pd='2*int((nf+1)/2) * (W/nf + 0.18u)'
+ ps='2*int((nf+2)/2) * (W/nf + 0.18u)' nrd='0.18u / W' nrs='0.18u / W' sa=0 sb=0 sd=0 m=1
XMIN2 B2B B2 VSS VSS nfet_03v3 L=0.28u W=1u nf=1 ad='int((nf+1)/2) * W/nf * 0.18u' as='int((nf+2)/2) * W/nf * 0.18u' pd='2*int((nf+1)/2) * (W/nf + 0.18u)'
+ ps='2*int((nf+2)/2) * (W/nf + 0.18u)' nrd='0.18u / W' nrs='0.18u / W' sa=0 sb=0 sd=0 m=1
XMA0 VBN1 VBP0 VDD VDD pfet_03v3 L=1u W=26.5u nf=2 ad='int((nf+1)/2) * W/nf * 0.18u' as='int((nf+2)/2) * W/nf * 0.18u' pd='2*int((nf+1)/2) * (W/nf + 0.18u)'
+ ps='2*int((nf+2)/2) * (W/nf + 0.18u)' nrd='0.18u / W' nrs='0.18u / W' sa=0 sb=0 sd=0 m=1
XMA1 VBN1 GA VDD VDD pfet_03v3 L=1u W=17.225u nf=2 ad='int((nf+1)/2) * W/nf * 0.18u' as='int((nf+2)/2) * W/nf * 0.18u' pd='2*int((nf+1)/2) * (W/nf + 0.18u)'
+ ps='2*int((nf+2)/2) * (W/nf + 0.18u)' nrd='0.18u / W' nrs='0.18u / W' sa=0 sb=0 sd=0 m=1
XMSWA0 GA B0B VBP0 VDD pfet_03v3 L=0.5u W=2u nf=1 ad='int((nf+1)/2) * W/nf * 0.18u' as='int((nf+2)/2) * W/nf * 0.18u' pd='2*int((nf+1)/2) * (W/nf + 0.18u)'
+ ps='2*int((nf+2)/2) * (W/nf + 0.18u)' nrd='0.18u / W' nrs='0.18u / W' sa=0 sb=0 sd=0 m=1
XMSWA1 GA B0 VDD VDD pfet_03v3 L=0.5u W=2u nf=1 ad='int((nf+1)/2) * W/nf * 0.18u' as='int((nf+2)/2) * W/nf * 0.18u' pd='2*int((nf+1)/2) * (W/nf + 0.18u)'
+ ps='2*int((nf+2)/2) * (W/nf + 0.18u)' nrd='0.18u / W' nrs='0.18u / W' sa=0 sb=0 sd=0 m=1
XMDA VBN1 VBN1 VSS VSS nfet_03v3 L=1u W=10u nf=1 ad='int((nf+1)/2) * W/nf * 0.18u' as='int((nf+2)/2) * W/nf * 0.18u' pd='2*int((nf+1)/2) * (W/nf + 0.18u)'
+ ps='2*int((nf+2)/2) * (W/nf + 0.18u)' nrd='0.18u / W' nrs='0.18u / W' sa=0 sb=0 sd=0 m=1
XMB0 VBP2 VBN1 VSS VSS nfet_03v3 L=1u W=5u nf=1 ad='int((nf+1)/2) * W/nf * 0.18u' as='int((nf+2)/2) * W/nf * 0.18u' pd='2*int((nf+1)/2) * (W/nf + 0.18u)'
+ ps='2*int((nf+2)/2) * (W/nf + 0.18u)' nrd='0.18u / W' nrs='0.18u / W' sa=0 sb=0 sd=0 m=1
XMB1 VBP2 GB VSS VSS nfet_03v3 L=1u W=8.6125u nf=1 ad='int((nf+1)/2) * W/nf * 0.18u' as='int((nf+2)/2) * W/nf * 0.18u' pd='2*int((nf+1)/2) * (W/nf + 0.18u)'
+ ps='2*int((nf+2)/2) * (W/nf + 0.18u)' nrd='0.18u / W' nrs='0.18u / W' sa=0 sb=0 sd=0 m=1
XMSWB0 GB B1 VBN1 VSS nfet_03v3 L=0.5u W=2u nf=1 ad='int((nf+1)/2) * W/nf * 0.18u' as='int((nf+2)/2) * W/nf * 0.18u' pd='2*int((nf+1)/2) * (W/nf + 0.18u)'
+ ps='2*int((nf+2)/2) * (W/nf + 0.18u)' nrd='0.18u / W' nrs='0.18u / W' sa=0 sb=0 sd=0 m=1
XMSWB1 GB B1B VSS VSS nfet_03v3 L=0.5u W=2u nf=1 ad='int((nf+1)/2) * W/nf * 0.18u' as='int((nf+2)/2) * W/nf * 0.18u' pd='2*int((nf+1)/2) * (W/nf + 0.18u)'
+ ps='2*int((nf+2)/2) * (W/nf + 0.18u)' nrd='0.18u / W' nrs='0.18u / W' sa=0 sb=0 sd=0 m=1
XMDB VBP2 VBP2 VDD VDD pfet_03v3 L=1u W=20u nf=1 ad='int((nf+1)/2) * W/nf * 0.18u' as='int((nf+2)/2) * W/nf * 0.18u' pd='2*int((nf+1)/2) * (W/nf + 0.18u)'
+ ps='2*int((nf+2)/2) * (W/nf + 0.18u)' nrd='0.18u / W' nrs='0.18u / W' sa=0 sb=0 sd=0 m=1
XMC0 VBN VBP2 VDD VDD pfet_03v3 L=1u W=12.3u nf=1 ad='int((nf+1)/2) * W/nf * 0.18u' as='int((nf+2)/2) * W/nf * 0.18u' pd='2*int((nf+1)/2) * (W/nf + 0.18u)'
+ ps='2*int((nf+2)/2) * (W/nf + 0.18u)' nrd='0.18u / W' nrs='0.18u / W' sa=0 sb=0 sd=0 m=1
XMC1 VBN GC VDD VDD pfet_03v3 L=1u W=78.87u nf=8 ad='int((nf+1)/2) * W/nf * 0.18u' as='int((nf+2)/2) * W/nf * 0.18u' pd='2*int((nf+1)/2) * (W/nf + 0.18u)'
+ ps='2*int((nf+2)/2) * (W/nf + 0.18u)' nrd='0.18u / W' nrs='0.18u / W' sa=0 sb=0 sd=0 m=1
XMSWC0 GC B2B VBP2 VDD pfet_03v3 L=0.5u W=2u nf=1 ad='int((nf+1)/2) * W/nf * 0.18u' as='int((nf+2)/2) * W/nf * 0.18u' pd='2*int((nf+1)/2) * (W/nf + 0.18u)'
+ ps='2*int((nf+2)/2) * (W/nf + 0.18u)' nrd='0.18u / W' nrs='0.18u / W' sa=0 sb=0 sd=0 m=1
XMSWC1 GC B2 VDD VDD pfet_03v3 L=0.5u W=2u nf=1 ad='int((nf+1)/2) * W/nf * 0.18u' as='int((nf+2)/2) * W/nf * 0.18u' pd='2*int((nf+1)/2) * (W/nf + 0.18u)'
+ ps='2*int((nf+2)/2) * (W/nf + 0.18u)' nrd='0.18u / W' nrs='0.18u / W' sa=0 sb=0 sd=0 m=1
XMDN VBN VBN VSS VSS nfet_03v3 L=0.5u W=4u nf=1 ad='int((nf+1)/2) * W/nf * 0.18u' as='int((nf+2)/2) * W/nf * 0.18u' pd='2*int((nf+1)/2) * (W/nf + 0.18u)'
+ ps='2*int((nf+2)/2) * (W/nf + 0.18u)' nrd='0.18u / W' nrs='0.18u / W' sa=0 sb=0 sd=0 m=1
XMMN VBP VBN VSS VSS nfet_03v3 L=0.5u W=4u nf=1 ad='int((nf+1)/2) * W/nf * 0.18u' as='int((nf+2)/2) * W/nf * 0.18u' pd='2*int((nf+1)/2) * (W/nf + 0.18u)'
+ ps='2*int((nf+2)/2) * (W/nf + 0.18u)' nrd='0.18u / W' nrs='0.18u / W' sa=0 sb=0 sd=0 m=1
XMDP VBP VBP VDD VDD pfet_03v3 L=0.5u W=10u nf=1 ad='int((nf+1)/2) * W/nf * 0.18u' as='int((nf+2)/2) * W/nf * 0.18u' pd='2*int((nf+1)/2) * (W/nf + 0.18u)'
+ ps='2*int((nf+2)/2) * (W/nf + 0.18u)' nrd='0.18u / W' nrs='0.18u / W' sa=0 sb=0 sd=0 m=1
.ends

* expanding   symbol:  vco_stage.sym # of pins=6
** sym_path: design/vco_stage.sym
** sch_path: design/vco_stage.sch
.subckt vco_stage A Y VDD VSS VBP VBN
*.ipin A
*.opin Y
*.iopin VDD
*.iopin VSS
*.iopin VBP
*.iopin VBN
XMPH NH VBP VDD VDD pfet_03v3 L=0.5u W=10u nf=1 ad='int((nf+1)/2) * W/nf * 0.18u' as='int((nf+2)/2) * W/nf * 0.18u' pd='2*int((nf+1)/2) * (W/nf + 0.18u)'
+ ps='2*int((nf+2)/2) * (W/nf + 0.18u)' nrd='0.18u / W' nrs='0.18u / W' sa=0 sb=0 sd=0 m=1
XMP Y A NH VDD pfet_03v3 L=0.28u W=5u nf=1 ad='int((nf+1)/2) * W/nf * 0.18u' as='int((nf+2)/2) * W/nf * 0.18u' pd='2*int((nf+1)/2) * (W/nf + 0.18u)'
+ ps='2*int((nf+2)/2) * (W/nf + 0.18u)' nrd='0.18u / W' nrs='0.18u / W' sa=0 sb=0 sd=0 m=1
XMN Y A NT VSS nfet_03v3 L=0.28u W=2u nf=1 ad='int((nf+1)/2) * W/nf * 0.18u' as='int((nf+2)/2) * W/nf * 0.18u' pd='2*int((nf+1)/2) * (W/nf + 0.18u)'
+ ps='2*int((nf+2)/2) * (W/nf + 0.18u)' nrd='0.18u / W' nrs='0.18u / W' sa=0 sb=0 sd=0 m=1
XMNT NT VBN VSS VSS nfet_03v3 L=0.5u W=4u nf=1 ad='int((nf+1)/2) * W/nf * 0.18u' as='int((nf+2)/2) * W/nf * 0.18u' pd='2*int((nf+1)/2) * (W/nf + 0.18u)'
+ ps='2*int((nf+2)/2) * (W/nf + 0.18u)' nrd='0.18u / W' nrs='0.18u / W' sa=0 sb=0 sd=0 m=1
.ends

* ---- sim/vco-tuning-range/testbench-supply/tb_vco_pushing.spice (sha256 eae2b3ba3744dddb24222980b23ce746a81c6b26933415dcb00261f9ab7c378d)
* gf180-pll :: vco-tuning-range :: supply pushing, f_osc vs. vdd_vco
*
* sim/harness netlist FRAGMENT (see sim/harness/README.md), and the `push`
* phase of the two-deck supply manifest next to this file. The DUT is the
* committed export design/netlist/vco.spice, composed ahead of this fragment by
* the manifest's `dut` key -- this file instantiates the block, it never
* contains a copy of it.
*
* Migrated from the sim/lib/simenv.sh-based tb_vco_pushing.sp + run_supply.sh
* pair (issue #43). The measured circuit and the measurement criterion are
* unchanged: same seven-copy topology, same rail-referenced band-code drive,
* same .ic start-up, same trig/targ period criterion, same seven supply points.
*
* Measurement topology
*   Seven independent copies of the whole VCO, one per supply voltage, spanning
*   the ratified 3.3 V +/-10 % rail in 0.11 V steps (2.97 .. 3.63 V, the
*   manifest's vs1..vs7). Each copy has its OWN supply source, its OWN supply
*   ammeter and its OWN band-code sources referenced to that copy's rail -- a
*   shared logic-level band code would leave the band-select pass gates of the
*   higher-rail copies partly on and corrupt the very quantity being measured.
*
*   Frequency is measured at the buffered output CLK of each copy, over four
*   whole cycles after `w_settle`, against that copy's own half-supply
*   threshold.
*
*   This deck characterizes STATIC pushing (dc supply -> dc frequency). It says
*   nothing about the jitter a supply *transient* produces; that is the `jit`
*   phase (tb_vco_supply_jitter.spice), and DR-001 names it the top risk for
*   this topology. The two are one record because the jitter numbers are not
*   interpretable without these.
*
*   The deck's own supply axis is internal, so `vdd_val` is deliberately unused
*   here: this fragment measures f(vdd) over its own seven copies at whatever
*   PVT point the harness places it. Where the shared grid runs this phase at
*   more than one PVT supply (the band-5 blocks, which exist for the jitter
*   deck), those runs are byte-identical circuits and must return identical
*   numbers -- the migration check in derive_supply.py asserts exactly that.
*
* Devices are PDK 3.3 V thick-oxide wrappers only (DR-002 Decision 3).
*
* From the harness: vdd_val, vdd_nom, temp_c.
* From the manifest's shared params: vctrl, vs1..vs7.
* From the manifest's `band` sweep axis: band, b0, b1, b2.
* From the manifest's `fcal` sweep axis: w_fres (see below).

* ---------------------------------------------------------------------------
* Transient window, sized in-deck.
*
* The window has to track f_osc, which moves by ~2 decades across the band
* codes and by ~4x across PVT. The pre-migration runner computed it in bash
* (testbench/common.sh :: f_est); the harness owns the .tran card, so the same
* estimator is expressed here as .param arithmetic over the quantities the deck
* can see, and handed to the control block through .csparam.
*
* This is the SAME estimator, term for term, that minted the record this
* campaign supersedes. It is preserved rather than improved on purpose: the
* jitter phase's ripple frequency is defined as f_osc/N, so the estimator is
* part of the *stimulus*, and changing it would make the migrated record a
* different experiment rather than the same one re-run. Here, where it only
* sizes a window, its accuracy costs runtime and never correctness -- an
* estimate wrong enough to lose a rising edge makes the .measure fail and the
* harness reports that point as failed.
*
*   f_est = 4.5e6 * 1.65^band * (1 + (Vctrl-0.9)/1.33) * f_temp * f_res * f_vdd
*
*   1.65^band       exp(band*ln(1.65)); band is an integer 0..7 axis param
*   Vctrl factor    1.6766917293233083 at the campaign's fixed Vctrl = 1.8 V
*   f_temp          0.75 / 1.00 / 1.35 at -40 / 27 / 125 C. Written as the
*                   quadratic through those three points, which reproduces
*                   them EXACTLY (three points, three coefficients) and
*                   interpolates sanely if the grid is ever run off them.
*   f_res           the process axis, which a fragment cannot see -- supplied
*                   as `w_fres` by the manifest's `fcal` sweep axis, whose grid
*                   blocks pair it with the corner bundles it calibrates
*                   (1.00 for the five MOS-only bundles, 0.80 all-slow,
*                   1.25 all-fast). It is a calibration constant of the
*                   estimator, NOT a model corner and NOT a result.
*   f_vdd           1 + (3.30 - vdd)*0.36, evaluated per copy.
.param w_fband='exp(band*0.50077528791248915)'
.param w_ft='0.90030044582283386 + 0.0037187439426245397*temp_c - 9.6918007365767916e-07*temp_c*temp_c'
.param w_fbase='4.5e6 * w_fband * 1.6766917293233083 * w_ft * w_fres'
* f_vdd falls monotonically with vdd, so the slowest copy is the vs7 one and
* the fastest is the vs1 one: the window is sized by the slowest and the
* timestep by the fastest, exactly as the bash runner did.
.param w_flo='w_fbase * (1 + (3.30 - vs7) * 0.36)'
.param w_fhi='w_fbase * (1 + (3.30 - vs1) * 0.36)'
* >= 4 periods of the slowest copy before the first measured edge, then 7 more
* periods of measurement window; <= 1/(80 f_max), i.e. >= 80 timesteps per
* cycle of the fastest copy in the deck.
.param w_settle='4 / w_flo'
.param w_stop='w_settle + 7 / w_flo'
.param w_max='1 / (80 * w_fhi)'
.csparam cs_stop={w_stop}
.csparam cs_max={w_max}

vc vctl 0 dc 'vctrl'

* --- copy 1
v1  n1  0 dc 'vs1'
vam1 n1  m1 dc 0
vq1a q1a 0 dc 'b0*vs1'
vq1b q1b 0 dc 'b1*vs1'
vq1c q1c 0 dc 'b2*vs1'
x1 vctl q1a q1b q1c clk1 m1 0 vco
* --- copy 2
v2  n2  0 dc 'vs2'
vam2 n2  m2 dc 0
vq2a q2a 0 dc 'b0*vs2'
vq2b q2b 0 dc 'b1*vs2'
vq2c q2c 0 dc 'b2*vs2'
x2 vctl q2a q2b q2c clk2 m2 0 vco
* --- copy 3
v3  n3  0 dc 'vs3'
vam3 n3  m3 dc 0
vq3a q3a 0 dc 'b0*vs3'
vq3b q3b 0 dc 'b1*vs3'
vq3c q3c 0 dc 'b2*vs3'
x3 vctl q3a q3b q3c clk3 m3 0 vco
* --- copy 4
v4  n4  0 dc 'vs4'
vam4 n4  m4 dc 0
vq4a q4a 0 dc 'b0*vs4'
vq4b q4b 0 dc 'b1*vs4'
vq4c q4c 0 dc 'b2*vs4'
x4 vctl q4a q4b q4c clk4 m4 0 vco
* --- copy 5
v5  n5  0 dc 'vs5'
vam5 n5  m5 dc 0
vq5a q5a 0 dc 'b0*vs5'
vq5b q5b 0 dc 'b1*vs5'
vq5c q5c 0 dc 'b2*vs5'
x5 vctl q5a q5b q5c clk5 m5 0 vco
* --- copy 6
v6  n6  0 dc 'vs6'
vam6 n6  m6 dc 0
vq6a q6a 0 dc 'b0*vs6'
vq6b q6b 0 dc 'b1*vs6'
vq6c q6c 0 dc 'b2*vs6'
x6 vctl q6a q6b q6c clk6 m6 0 vco
* --- copy 7
v7  n7  0 dc 'vs7'
vam7 n7  m7 dc 0
vq7a q7a 0 dc 'b0*vs7'
vq7b q7b 0 dc 'b1*vs7'
vq7c q7c 0 dc 'b2*vs7'
x7 vctl q7a q7b q7c clk7 m7 0 vco

* Break the ring's metastable all-nodes-at-mid DC solution. `uic` is NOT used:
* every bias generator is solved to its operating point before t=0.
.ic v(x1.Y1)=0 v(x1.Y2)='vs1' v(x1.Y3)=0 v(x1.Y4)='vs1' v(x1.Y5)=0
.ic v(x2.Y1)=0 v(x2.Y2)='vs2' v(x2.Y3)=0 v(x2.Y4)='vs2' v(x2.Y5)=0
.ic v(x3.Y1)=0 v(x3.Y2)='vs3' v(x3.Y3)=0 v(x3.Y4)='vs3' v(x3.Y5)=0
.ic v(x4.Y1)=0 v(x4.Y2)='vs4' v(x4.Y3)=0 v(x4.Y4)='vs4' v(x4.Y5)=0
.ic v(x5.Y1)=0 v(x5.Y2)='vs5' v(x5.Y3)=0 v(x5.Y4)='vs5' v(x5.Y5)=0
.ic v(x6.Y1)=0 v(x6.Y2)='vs6' v(x6.Y3)=0 v(x6.Y4)='vs6' v(x6.Y5)=0
.ic v(x7.Y1)=0 v(x7.Y2)='vs7' v(x7.Y3)=0 v(x7.Y4)='vs7' v(x7.Y5)=0

* ---- sim/vco-tuning-range/testbench-supply/tb_vco_supply_jitter.spice (sha256 0b8295b1663d8aa59cbb8c020b10014e42d7fdd2e1ac5e073343ae0e22f499c2)
* gf180-pll :: vco-tuning-range :: supply-step and supply-ripple jitter
*
* sim/harness netlist FRAGMENT (see sim/harness/README.md), and the `jit` phase
* of the two-deck supply manifest next to this file. The DUT is the committed
* export design/netlist/vco.spice, composed ahead of this fragment by the
* manifest's `dut` key.
*
* Migrated from the sim/lib/simenv.sh-based tb_vco_supply_jitter.sp +
* run_supply.sh pair (issue #43). The measured circuit, the stimulus and the
* extraction criterion are unchanged: same three-copy topology, same
* rail-tracking band code, same .ic start-up, same 0.1 V step / 0.05 V ripple,
* the same window (6 settle periods + 4 whole ripple periods, >= 64 cycles,
* step at the window midpoint), and the same interpolated half-supply-crossing
* extraction -- now in derive_supply.py instead of jitter_extract.py.
*
* DR-001's Consequences section names supply noise the accepted risk of the
* current-starved single-ended ring, and names this testbench as the evidence
* #8 owes: "a supply-step/supply-noise jitter testbench, not just a
* clean-supply Kvco sweep. This is the number most likely to force a
* supersede."
*
* Measurement topology -- three independent copies of the whole VCO at one PVT
* point, one band code and one control voltage, differing ONLY in what drives
* their supply rail:
*
*   XQ  quiet rail, dc vdd_val. This copy is the **numerical noise floor**: any
*       cycle-to-cycle variation it shows is the transient solver's own local
*       truncation error, not circuit behaviour. Every jitter number from the
*       other two copies is reported against this floor, so the record can say
*       whether the supply-induced jitter is resolvable at all.
*   XS  rail with a single fast STEP of `astep` volts at t = `w_stepon`,
*       `tedge` edge. Gives the transient supply-pushing coefficient (which is
*       not assumed equal to the dc one) and the timing error a supply droop
*       accumulates while the loop has not yet corrected it.
*   XR  rail with a sinusoidal RIPPLE of amplitude `arip` at `w_frip`. Gives
*       peak-to-peak / RMS period jitter and the peak-to-peak time interval
*       error (TIE), which is the quantity a jitter budget actually consumes.
*
* Each copy's 3-bit band code is generated by a VCVS from that copy's own rail,
* so the static band-select code tracks the perturbed supply exactly rather
* than presenting a stale logic level to the band-select pass gates.
*
* No `.measure` reports a jitter number here. The three buffered outputs are
* written to `jit.dat` (the manifest's `raw_files`) and every reported number
* is extracted from interpolated half-supply crossings by derive_supply.py --
* `.measure` cannot report a per-cycle period sequence, and the period
* *sequence* is what jitter is. The three `.measure`d quantities the manifest
* does declare for this deck (`jsettle`, `jstepon`, `jfrip`) are the deck's own
* window parameters, reported so the reduction uses the values the simulation
* actually ran with rather than recomputing them.
*
* Devices are PDK 3.3 V thick-oxide wrappers only (DR-002 Decision 3).
*
* From the harness: vdd_val, vdd_nom, temp_c.
* From the manifest's shared params: vctrl, astep, arip, tedge.
* From the manifest's `band` sweep axis: band, b0, b1, b2.
* From the manifest's `rdiv` sweep axis: w_rdiv, w_ncyc.
* From the manifest's `fcal` sweep axis: w_fres.

* Tighter than the ngspice default (1e-3) so the quiet copy's numerical jitter
* floor sits well below the supply-induced jitter being measured. Declared as
* the phase's `options` in the manifest, not here -- a fragment does not own
* simulator settings. (Kept in this comment because the floor claim in the
* record depends on it.)

* ---------------------------------------------------------------------------
* Transient window and ripple frequency, sized in-deck.
*
* Identical estimator to the `push` phase's -- see tb_vco_pushing.spice for the
* full derivation and for why it is preserved verbatim from the pre-migration
* bash runner rather than improved. Here it is not only a window: `w_frip` IS
* the stimulus, because the campaign's ripple frequency is specified as
* f_osc/N. That is why the process-dependent term `w_fres` has to reach the
* deck at all (via the manifest's `fcal` axis) -- a ripple defined relative to
* f_osc cannot be corner-blind.
.param w_fband='exp(band*0.50077528791248915)'
.param w_ft='0.90030044582283386 + 0.0037187439426245397*temp_c - 9.6918007365767916e-07*temp_c*temp_c'
.param w_f='4.5e6 * w_fband * 1.6766917293233083 * w_ft * w_fres * (1 + (3.30 - vdd_val) * 0.36)'
* 6 estimated periods of settling, then a window holding w_ncyc whole cycles.
* w_ncyc is always >= 64 cycles AND >= 4 whole ripple periods, so the
* peak-to-peak TIE the record reports is a real peak-to-peak and not a fragment
* of one modulation cycle. The step lands at the window midpoint.
.param w_settle='6 / w_f'
.param w_win='w_ncyc / w_f'
.param w_stop='w_settle + w_win'
.param w_stepon='w_settle + w_win / 2'
.param w_max='1 / (200 * w_f)'
.param w_frip='w_f / w_rdiv'
.csparam cs_stop={w_stop}
.csparam cs_max={w_max}

vc vctl 0 dc 'vctrl'

*----------------------------------------------------- XQ: quiet reference rail
vq nq 0 dc 'vdd_val'
eqa qa 0 nq 0 'b0'
eqb qb 0 nq 0 'b1'
eqc qc 0 nq 0 'b2'
xq vctl qa qb qc clkq nq 0 vco

*---------------------------------------------------------- XS: supply step
vsd nsd 0 dc 'vdd_val'
vst nst nsd pulse(0 'astep' 'w_stepon' 'tedge' 'tedge' 1 2)
esa sa 0 nst 0 'b0'
esb sb 0 nst 0 'b1'
esc sc 0 nst 0 'b2'
xs vctl sa sb sc clks nst 0 vco

*--------------------------------------------------------- XR: supply ripple
vrd nrd 0 dc 'vdd_val'
vrp nrp nrd sin(0 'arip' 'w_frip')
era ra 0 nrp 0 'b0'
erb rb 0 nrp 0 'b1'
erc rc 0 nrp 0 'b2'
xr vctl ra rb rc clkr nrp 0 vco

* Break the ring's metastable all-nodes-at-mid DC solution. `uic` is NOT used:
* every bias generator is solved to its operating point before t=0.
.ic v(xq.Y1)=0 v(xq.Y2)='vdd_val' v(xq.Y3)=0 v(xq.Y4)='vdd_val' v(xq.Y5)=0
.ic v(xs.Y1)=0 v(xs.Y2)='vdd_val' v(xs.Y3)=0 v(xs.Y4)='vdd_val' v(xs.Y5)=0
.ic v(xr.Y1)=0 v(xr.Y2)='vdd_val' v(xr.Y3)=0 v(xr.Y4)='vdd_val' v(xr.Y5)=0
