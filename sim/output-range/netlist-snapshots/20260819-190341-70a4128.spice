* ==== deck 1 of 2: sim/output-range/work/dut_output_range.sp ====
* The campaign deck. Both the CAPPED row and the seed-perturbed
* diagnostic row below were run from this deck, unmodified.
* ASSEMBLED by sim/lib/pll_top_dut.sh -- do not edit.
* DUT: design/netlist/pll_top.spice (export of design/pll_top.sch, #52)
* Stimulus: sim/output-range/testbench/tb_output_range.sp
* gf180-pll :: pll_top -- generated by design/netlist.sh from pll_top.sch
* xschem XSCHEM V3.4.7; do not edit by hand.
** sch_path: design/pll_top.sch
.subckt pll_top REF B0 B1 B2 CPB0 CPB1 P0 P1 P2 P3 P4 P5 SEL0 SEL1 SEL2 SEL3 SEL4 SEL5 IBN ICN IBP ICP CLK DIVOUT FB LOCK VCTRL
+ VDD VDD_VCO GND_VCO VDD_DIV VSS
*.ipin REF
*.ipin B0
*.ipin B1
*.ipin B2
*.ipin CPB0
*.ipin CPB1
*.ipin P0
*.ipin P1
*.ipin P2
*.ipin P3
*.ipin P4
*.ipin P5
*.ipin SEL0
*.ipin SEL1
*.ipin SEL2
*.ipin SEL3
*.ipin SEL4
*.ipin SEL5
*.ipin IBN
*.ipin ICN
*.ipin IBP
*.ipin ICP
*.opin CLK
*.opin DIVOUT
*.opin FB
*.opin LOCK
*.iopin VCTRL
*.iopin VDD
*.iopin VDD_VCO
*.iopin GND_VCO
*.iopin VDD_DIV
*.iopin VSS
XPFD REF FB CPB0 CPB1 IBN ICN IBP ICP VCTRL UP DN VDD VSS pfd_cp
XLF VCTRL VSS loop_filter
XVCO VCTRL B0 B1 B2 CLK VDD_VCO GND_VCO vco
XDIV CLK P0 P1 P2 P3 P4 P5 SEL0 SEL1 SEL2 SEL3 SEL4 SEL5 DIVOUT FB VDD_DIV VSS divider_chain
XLD UP DN LOCK VWIN VDD VSS lock_detector
.ends

* expanding   symbol:  pfd_cp.sym # of pins=13
** sym_path: design/pfd_cp.sym
** sch_path: design/pfd_cp.sch
.subckt pfd_cp REF FB B0 B1 IBN ICN IBP ICP VOUT UP DN VDD VSS
*.ipin REF
*.ipin FB
*.ipin B0
*.ipin B1
*.iopin IBN
*.iopin ICN
*.iopin IBP
*.iopin ICP
*.iopin VOUT
*.opin UP
*.opin DN
*.iopin VDD
*.iopin VSS
xpfd REF FB UP DN VDD VSS pfd
xcp UP DN B0 B1 IBN ICN IBP ICP VOUT VDD VSS cp
.ends

* expanding   symbol:  loop_filter.sym # of pins=2
** sym_path: design/loop_filter.sym
** sch_path: design/loop_filter.sch
.subckt loop_filter VCTRL VSS
*.iopin VCTRL
*.iopin VSS
XRF1 NR1 VCTRL VSS ppolyf_u r_width=2u r_length=107u m=1
XRF2 NR2 NR1 VSS ppolyf_u r_width=2u r_length=107u m=1
XRF3 NR3 NR2 VSS ppolyf_u r_width=2u r_length=107u m=1
XRF4 NZ NR3 VSS ppolyf_u r_width=2u r_length=107u m=1
XCF1 NZ VSS cap_nmos_03v3_b c_width=87u c_length=87u m=1
XCF2 NZ VSS cap_nmos_03v3_b c_width=87u c_length=87u m=1
XCF3 NZ VSS cap_nmos_03v3_b c_width=87u c_length=87u m=1
XCF4 NZ VSS cap_nmos_03v3_b c_width=87u c_length=87u m=1
XCF5 VCTRL VSS cap_mim_2f0_m2m3_noshield c_width=31.4u c_length=31.4u m=1
.ends

* expanding   symbol:  vco.sym # of pins=7
** sym_path: design/vco.sym
** sch_path: design/vco.sch
.subckt vco VCTRL B0 B1 B2 CLK VDD_VCO GND_VCO
*.ipin VCTRL
*.ipin B0
*.ipin B1
*.ipin B2
*.opin CLK
*.iopin VDD_VCO
*.iopin GND_VCO
XBIAS VCTRL B0 B1 B2 VBP VBN VDD_VCO GND_VCO vco_bias
XS1 Y5 Y1 VDD_VCO GND_VCO VBP VBN vco_stage
XS2 Y1 Y2 VDD_VCO GND_VCO VBP VBN vco_stage
XS3 Y2 Y3 VDD_VCO GND_VCO VBP VBN vco_stage
XS4 Y3 Y4 VDD_VCO GND_VCO VBP VBN vco_stage
XS5 Y4 Y5 VDD_VCO GND_VCO VBP VBN vco_stage
XMBP1 NB1 Y5 VDD_VCO VDD_VCO pfet_03v3 L=0.28u W=1.25u nf=1 ad='int((nf+1)/2) * W/nf * 0.18u' as='int((nf+2)/2) * W/nf * 0.18u' pd='2*int((nf+1)/2) * (W/nf + 0.18u)'
+ ps='2*int((nf+2)/2) * (W/nf + 0.18u)' nrd='0.18u / W' nrs='0.18u / W' sa=0 sb=0 sd=0 m=1
XMBN1 NB1 Y5 GND_VCO GND_VCO nfet_03v3 L=0.28u W=0.5u nf=1 ad='int((nf+1)/2) * W/nf * 0.18u' as='int((nf+2)/2) * W/nf * 0.18u' pd='2*int((nf+1)/2) * (W/nf + 0.18u)'
+ ps='2*int((nf+2)/2) * (W/nf + 0.18u)' nrd='0.18u / W' nrs='0.18u / W' sa=0 sb=0 sd=0 m=1
XMBP2 NB2 NB1 VDD_VCO VDD_VCO pfet_03v3 L=0.28u W=3.75u nf=1 ad='int((nf+1)/2) * W/nf * 0.18u' as='int((nf+2)/2) * W/nf * 0.18u' pd='2*int((nf+1)/2) * (W/nf + 0.18u)'
+ ps='2*int((nf+2)/2) * (W/nf + 0.18u)' nrd='0.18u / W' nrs='0.18u / W' sa=0 sb=0 sd=0 m=1
XMBN2 NB2 NB1 GND_VCO GND_VCO nfet_03v3 L=0.28u W=1.5u nf=1 ad='int((nf+1)/2) * W/nf * 0.18u' as='int((nf+2)/2) * W/nf * 0.18u' pd='2*int((nf+1)/2) * (W/nf + 0.18u)'
+ ps='2*int((nf+2)/2) * (W/nf + 0.18u)' nrd='0.18u / W' nrs='0.18u / W' sa=0 sb=0 sd=0 m=1
XMBP3 CLK NB2 VDD_VCO VDD_VCO pfet_03v3 L=0.28u W=11.25u nf=1 ad='int((nf+1)/2) * W/nf * 0.18u' as='int((nf+2)/2) * W/nf * 0.18u' pd='2*int((nf+1)/2) * (W/nf + 0.18u)'
+ ps='2*int((nf+2)/2) * (W/nf + 0.18u)' nrd='0.18u / W' nrs='0.18u / W' sa=0 sb=0 sd=0 m=1
XMBN3 CLK NB2 GND_VCO GND_VCO nfet_03v3 L=0.28u W=4.5u nf=1 ad='int((nf+1)/2) * W/nf * 0.18u' as='int((nf+2)/2) * W/nf * 0.18u' pd='2*int((nf+1)/2) * (W/nf + 0.18u)'
+ ps='2*int((nf+2)/2) * (W/nf + 0.18u)' nrd='0.18u / W' nrs='0.18u / W' sa=0 sb=0 sd=0 m=1
XCDEC1 VDD_VCO GND_VCO cap_nmos_03v3 c_width=50u c_length=50u m=1
XCDEC2 VDD_VCO GND_VCO cap_nmos_03v3 c_width=50u c_length=50u m=1
.ends

* expanding   symbol:  divider_chain.sym # of pins=17
** sym_path: design/divider_chain.sym
** sch_path: design/divider_chain.sch
.subckt divider_chain VCO P0 P1 P2 P3 P4 P5 SEL0 SEL1 SEL2 SEL3 SEL4 SEL5 DIVOUT FB VDD_DIV VSS
*.ipin VCO
*.ipin P0
*.ipin P1
*.ipin P2
*.ipin P3
*.ipin P4
*.ipin P5
*.ipin SEL0
*.ipin SEL1
*.ipin SEL2
*.ipin SEL3
*.ipin SEL4
*.ipin SEL5
*.opin DIVOUT
*.opin FB
*.iopin VDD_DIV
*.iopin VSS
XD0 VCO MI0 P0 CK1 MO0 VDD_DIV VSS div23_cell
XD1 CK1 MI1 P1 CK2 MO1 VDD_DIV VSS div23_cell
XD2 CK2 MI2 P2 CK3 MO2 VDD_DIV VSS div23_cell
XD3 CK3 MI3 P3 CK4 MO3 VDD_DIV VSS div23_cell
XD4 CK4 MI4 P4 CK5 MO4 VDD_DIV VSS div23_cell
XD5 CK5 SEL5 P5 CK6 MO5 VDD_DIV VSS div23_cell
XNR0 MO1 SEL0 NMI0 VDD_DIV VSS nor2_3v3
XIV0 NMI0 MI0 VDD_DIV VSS inv_3v3
XNR1 MO2 SEL1 NMI1 VDD_DIV VSS nor2_3v3
XIV1 NMI1 MI1 VDD_DIV VSS inv_3v3
XNR2 MO3 SEL2 NMI2 VDD_DIV VSS nor2_3v3
XIV2 NMI2 MI2 VDD_DIV VSS inv_3v3
XNR3 MO4 SEL3 NMI3 VDD_DIV VSS nor2_3v3
XIV3 NMI3 MI3 VDD_DIV VSS inv_3v3
XNR4 MO5 SEL4 NMI4 VDD_DIV VSS nor2_3v3
XIV4 NMI4 MI4 VDD_DIV VSS inv_3v3
XM0 CK1 SEL0 T0 VDD_DIV VSS nand2_3v3
XM1 CK2 SEL1 T1 VDD_DIV VSS nand2_3v3
XM2 CK3 SEL2 T2 VDD_DIV VSS nand2_3v3
XM3 CK4 SEL3 T3 VDD_DIV VSS nand2_3v3
XM4 CK5 SEL4 T4 VDD_DIV VSS nand2_3v3
XM5 CK6 SEL5 T5 VDD_DIV VSS nand2_3v3
XMA T0 T1 T2 MA VDD_DIV VSS nand3_3v3
XMB T3 T4 T5 MB VDD_DIV VSS nand3_3v3
XMNO MA MB DIVOUTB VDD_DIV VSS nor2_3v3
XIDO DIVOUTB DIVOUT VDD_DIV VSS inv2x_3v3
XFRT DIVOUT VCO FB FBB VDD_DIV VSS dff_tg_3v3
.ends

* expanding   symbol:  lock_detector.sym # of pins=6
** sym_path: design/lock_detector.sym
** sch_path: design/lock_detector.sch
.subckt lock_detector UP DN LOCK VWIN VDD VSS
*.ipin UP
*.ipin DN
*.opin LOCK
*.opin VWIN
*.iopin VDD
*.iopin VSS
XERR UP DN ERR VDD VSS xor2_3v3
XDLY ERR ERRD VDD VSS delaywin_3v3
XNW ERR ERRD WIDEB VDD VSS nand2_3v3
XIW WIDEB WIDE VDD VSS inv_3v3
XMDNW VWIN WIDE VSS VSS nfet_03v3 L=0.5u W=2u nf=1 ad='int((nf+1)/2) * W/nf * 0.18u' as='int((nf+2)/2) * W/nf * 0.18u' pd='2*int((nf+1)/2) * (W/nf + 0.18u)'
+ ps='2*int((nf+2)/2) * (W/nf + 0.18u)' nrd='0.18u / W' nrs='0.18u / W' sa=0 sb=0 sd=0 m=1
XMUPW VWIN VSS VDD VDD pfet_03v3 L=20u W=0.22u nf=1 ad='int((nf+1)/2) * W/nf * 0.18u' as='int((nf+2)/2) * W/nf * 0.18u' pd='2*int((nf+1)/2) * (W/nf + 0.18u)'
+ ps='2*int((nf+2)/2) * (W/nf + 0.18u)' nrd='0.18u / W' nrs='0.18u / W' sa=0 sb=0 sd=0 m=1
XMCW VSS VWIN VSS VSS nfet_03v3 L=6u W=30u nf=1 ad='int((nf+1)/2) * W/nf * 0.18u' as='int((nf+2)/2) * W/nf * 0.18u' pd='2*int((nf+1)/2) * (W/nf + 0.18u)'
+ ps='2*int((nf+2)/2) * (W/nf + 0.18u)' nrd='0.18u / W' nrs='0.18u / W' sa=0 sb=0 sd=0 m=1
XSCH VWIN LOCKB VDD VSS schmitt_3v3
XILK LOCKB LOCK VDD VSS inv_3v3
.ends

* expanding   symbol:  pfd.sym # of pins=6
** sym_path: design/pfd.sym
** sch_path: design/pfd.sch
.subckt pfd REF FB UP DN VDD VSS
*.ipin REF
*.ipin FB
*.opin UP
*.opin DN
*.iopin VDD
*.iopin VSS
xed_ref REF PR VDD VSS edgedet
xed_fb FB PF VDD VSS edgedet
xinv_sr PR SBR VDD VSS pfdcp_inv_3v3
xinv_sf PF SBF VDD VSS pfdcp_inv_3v3
xlat_ref SBR RB UP UPB VDD VSS srlatch
xlat_fb SBF RB DN DNB VDD VSS srlatch
xnand_rst UP DN NRST VDD VSS pfdcp_nand2_3v3
xinv_r0 NRST RST_RAW VDD VSS pfdcp_inv_3v3
xd1 RST_RAW RD1 VDD VSS pfdcp_inv_3v3
xd2 RD1 RD2 VDD VSS pfdcp_inv_3v3
xd3 RD2 RD3 VDD VSS pfdcp_inv_3v3
xd4 RD3 RD4 VDD VSS pfdcp_inv_3v3
xd5 RD4 RD5 VDD VSS pfdcp_inv_3v3
xd6 RD5 RD6 VDD VSS pfdcp_inv_3v3
xd7 RD6 RD7 VDD VSS pfdcp_inv_3v3
xd8 RD7 RD8 VDD VSS pfdcp_inv_3v3
xd9 RD8 RD9 VDD VSS pfdcp_inv_3v3
xd10 RD9 RD10 VDD VSS pfdcp_inv_3v3
xd11 RD10 RD11 VDD VSS pfdcp_inv_3v3
xd12 RD11 RD12 VDD VSS pfdcp_inv_3v3
xd13 RD12 RD13 VDD VSS pfdcp_inv_3v3
xd14 RD13 RD14 VDD VSS pfdcp_inv_3v3
xd15 RD14 RD15 VDD VSS pfdcp_inv_3v3
xd16 RD15 RD16 VDD VSS pfdcp_inv_3v3
xd17 RD16 RD17 VDD VSS pfdcp_inv_3v3
xd18 RD17 RD18 VDD VSS pfdcp_inv_3v3
xd19 RD18 RD19 VDD VSS pfdcp_inv_3v3
xd20 RD19 RD20 VDD VSS pfdcp_inv_3v3
xd21 RD20 RD21 VDD VSS pfdcp_inv_3v3
xd22 RD21 RD22 VDD VSS pfdcp_inv_3v3
xd23 RD22 RD23 VDD VSS pfdcp_inv_3v3
xd24 RD23 RST_DLY VDD VSS pfdcp_inv_3v3
xinv_rb RST_DLY RB VDD VSS pfdcp_inv_3v3
.ends

* expanding   symbol:  cp.sym # of pins=11
** sym_path: design/cp.sym
** sch_path: design/cp.sch
.subckt cp UP DN B0 B1 IBN ICN IBP ICP VOUT VDD VSS
*.ipin UP
*.ipin DN
*.ipin B0
*.ipin B1
*.iopin IBN
*.iopin ICN
*.iopin IBP
*.iopin ICP
*.iopin VOUT
*.iopin VDD
*.iopin VSS
XMBN IBN IBN VSS VSS nfet_03v3 L=1u W=16u nf=1 ad='int((nf+1)/2) * W/nf * 0.18u' as='int((nf+2)/2) * W/nf * 0.18u' pd='2*int((nf+1)/2) * (W/nf + 0.18u)'
+ ps='2*int((nf+2)/2) * (W/nf + 0.18u)' nrd='0.18u / W' nrs='0.18u / W' sa=0 sb=0 sd=0 m=1
XMCN ICN ICN VSS VSS nfet_03v3 L=1u W=4u nf=1 ad='int((nf+1)/2) * W/nf * 0.18u' as='int((nf+2)/2) * W/nf * 0.18u' pd='2*int((nf+1)/2) * (W/nf + 0.18u)'
+ ps='2*int((nf+2)/2) * (W/nf + 0.18u)' nrd='0.18u / W' nrs='0.18u / W' sa=0 sb=0 sd=0 m=1
XMBP IBP IBP VDD VDD pfet_03v3 L=1u W=48u nf=1 ad='int((nf+1)/2) * W/nf * 0.18u' as='int((nf+2)/2) * W/nf * 0.18u' pd='2*int((nf+1)/2) * (W/nf + 0.18u)'
+ ps='2*int((nf+2)/2) * (W/nf + 0.18u)' nrd='0.18u / W' nrs='0.18u / W' sa=0 sb=0 sd=0 m=1
XMCP ICP ICP VDD VDD pfet_03v3 L=1u W=12u nf=1 ad='int((nf+1)/2) * W/nf * 0.18u' as='int((nf+2)/2) * W/nf * 0.18u' pd='2*int((nf+1)/2) * (W/nf + 0.18u)'
+ ps='2*int((nf+2)/2) * (W/nf + 0.18u)' nrd='0.18u / W' nrs='0.18u / W' sa=0 sb=0 sd=0 m=1
xi_b0 B0 B0B VDD VSS pfdcp_inv_3v3
xi_b1 B1 B1B VDD VSS pfdcp_inv_3v3
xi_up UP UPB VDD VSS pfdcp_inv_3v3
xi_dn DN DNB VDD VSS pfdcp_inv_3v3
xn_base IBN ICN VDD VSS DNT VSS cp_leg_n
xn_t0 IBN ICN B0 B0B DNT VSS cp_leg_n
xn_t1a IBN ICN B1 B1B DNT VSS cp_leg_n
xn_t1b IBN ICN B1 B1B DNT VSS cp_leg_n
xp_base IBP ICP VDD VSS UPT VDD cp_leg_p
xp_t0 IBP ICP B0 B0B UPT VDD cp_leg_p
xp_t1a IBP ICP B1 B1B UPT VDD cp_leg_p
xp_t1b IBP ICP B1 B1B UPT VDD cp_leg_p
XMSWDN VOUT DN DNT VSS nfet_03v3 L=0.3u W=6u nf=1 ad='int((nf+1)/2) * W/nf * 0.18u' as='int((nf+2)/2) * W/nf * 0.18u' pd='2*int((nf+1)/2) * (W/nf + 0.18u)'
+ ps='2*int((nf+2)/2) * (W/nf + 0.18u)' nrd='0.18u / W' nrs='0.18u / W' sa=0 sb=0 sd=0 m=1
XMDMPDN VDUMP DNB DNT VSS nfet_03v3 L=0.3u W=6u nf=1 ad='int((nf+1)/2) * W/nf * 0.18u' as='int((nf+2)/2) * W/nf * 0.18u' pd='2*int((nf+1)/2) * (W/nf + 0.18u)'
+ ps='2*int((nf+2)/2) * (W/nf + 0.18u)' nrd='0.18u / W' nrs='0.18u / W' sa=0 sb=0 sd=0 m=1
XMSWUP VOUT UPB UPT VDD pfet_03v3 L=0.3u W=6u nf=1 ad='int((nf+1)/2) * W/nf * 0.18u' as='int((nf+2)/2) * W/nf * 0.18u' pd='2*int((nf+1)/2) * (W/nf + 0.18u)'
+ ps='2*int((nf+2)/2) * (W/nf + 0.18u)' nrd='0.18u / W' nrs='0.18u / W' sa=0 sb=0 sd=0 m=1
XMDMPUP VDUMP UP UPT VDD pfet_03v3 L=0.3u W=6u nf=1 ad='int((nf+1)/2) * W/nf * 0.18u' as='int((nf+2)/2) * W/nf * 0.18u' pd='2*int((nf+1)/2) * (W/nf + 0.18u)'
+ ps='2*int((nf+2)/2) * (W/nf + 0.18u)' nrd='0.18u / W' nrs='0.18u / W' sa=0 sb=0 sd=0 m=1
XMDUMN VOUT DNB VOUT VSS nfet_03v3 L=0.3u W=3u nf=1 ad='int((nf+1)/2) * W/nf * 0.18u' as='int((nf+2)/2) * W/nf * 0.18u' pd='2*int((nf+1)/2) * (W/nf + 0.18u)'
+ ps='2*int((nf+2)/2) * (W/nf + 0.18u)' nrd='0.18u / W' nrs='0.18u / W' sa=0 sb=0 sd=0 m=1
XMDUMP VOUT UP VOUT VDD pfet_03v3 L=0.3u W=3u nf=1 ad='int((nf+1)/2) * W/nf * 0.18u' as='int((nf+2)/2) * W/nf * 0.18u' pd='2*int((nf+1)/2) * (W/nf + 0.18u)'
+ ps='2*int((nf+2)/2) * (W/nf + 0.18u)' nrd='0.18u / W' nrs='0.18u / W' sa=0 sb=0 sd=0 m=1
xbuf VOUT IBN IBP VDUMP VDD VSS cp_dumpbuf
.ends

* expanding   symbol:  vco_bias.sym # of pins=8
** sym_path: design/vco_bias.sym
** sch_path: design/vco_bias.sch
.subckt vco_bias VCTRL B0 B1 B2 VBP VBN VDD VSS
*.ipin VCTRL
*.ipin B0
*.ipin B1
*.ipin B2
*.iopin VBP
*.iopin VBN
*.iopin VDD
*.iopin VSS
XMP1 NA VBPC VDD VDD pfet_03v3 L=1u W=10u nf=1 ad='int((nf+1)/2) * W/nf * 0.18u' as='int((nf+2)/2) * W/nf * 0.18u' pd='2*int((nf+1)/2) * (W/nf + 0.18u)'
+ ps='2*int((nf+2)/2) * (W/nf + 0.18u)' nrd='0.18u / W' nrs='0.18u / W' sa=0 sb=0 sd=0 m=1
XMP2 VBPC VBPC VDD VDD pfet_03v3 L=1u W=10u nf=1 ad='int((nf+1)/2) * W/nf * 0.18u' as='int((nf+2)/2) * W/nf * 0.18u' pd='2*int((nf+1)/2) * (W/nf + 0.18u)'
+ ps='2*int((nf+2)/2) * (W/nf + 0.18u)' nrd='0.18u / W' nrs='0.18u / W' sa=0 sb=0 sd=0 m=1
XMN1 NA NA VSS VSS nfet_03v3 L=1u W=1.4u nf=1 ad='int((nf+1)/2) * W/nf * 0.18u' as='int((nf+2)/2) * W/nf * 0.18u' pd='2*int((nf+1)/2) * (W/nf + 0.18u)'
+ ps='2*int((nf+2)/2) * (W/nf + 0.18u)' nrd='0.18u / W' nrs='0.18u / W' sa=0 sb=0 sd=0 m=1
XMN2 VBPC NA NC VSS nfet_03v3 L=1u W=5.6u nf=1 ad='int((nf+1)/2) * W/nf * 0.18u' as='int((nf+2)/2) * W/nf * 0.18u' pd='2*int((nf+1)/2) * (W/nf + 0.18u)'
+ ps='2*int((nf+2)/2) * (W/nf + 0.18u)' nrd='0.18u / W' nrs='0.18u / W' sa=0 sb=0 sd=0 m=1
XRCG NC VSS VSS ppolyf_u_3k r_width=1u r_length=5.6u m=1
XMSU1 NSU VSS VDD VDD pfet_03v3 L=20u W=0.22u nf=1 ad='int((nf+1)/2) * W/nf * 0.18u' as='int((nf+2)/2) * W/nf * 0.18u' pd='2*int((nf+1)/2) * (W/nf + 0.18u)'
+ ps='2*int((nf+2)/2) * (W/nf + 0.18u)' nrd='0.18u / W' nrs='0.18u / W' sa=0 sb=0 sd=0 m=1
XMSU2 NSU NA VSS VSS nfet_03v3 L=1u W=2u nf=1 ad='int((nf+1)/2) * W/nf * 0.18u' as='int((nf+2)/2) * W/nf * 0.18u' pd='2*int((nf+1)/2) * (W/nf + 0.18u)'
+ ps='2*int((nf+2)/2) * (W/nf + 0.18u)' nrd='0.18u / W' nrs='0.18u / W' sa=0 sb=0 sd=0 m=1
XMSU3 VBPC NSU VSS VSS nfet_03v3 L=1u W=1u nf=1 ad='int((nf+1)/2) * W/nf * 0.18u' as='int((nf+2)/2) * W/nf * 0.18u' pd='2*int((nf+1)/2) * (W/nf + 0.18u)'
+ ps='2*int((nf+2)/2) * (W/nf + 0.18u)' nrd='0.18u / W' nrs='0.18u / W' sa=0 sb=0 sd=0 m=1
XMPR VFIX VBPC VDD VDD pfet_03v3 L=1u W=2.5u nf=1 ad='int((nf+1)/2) * W/nf * 0.18u' as='int((nf+2)/2) * W/nf * 0.18u' pd='2*int((nf+1)/2) * (W/nf + 0.18u)'
+ ps='2*int((nf+2)/2) * (W/nf + 0.18u)' nrd='0.18u / W' nrs='0.18u / W' sa=0 sb=0 sd=0 m=1
XMD1 VFIX VFIX NMD VSS nfet_03v3 L=1u W=2u nf=1 ad='int((nf+1)/2) * W/nf * 0.18u' as='int((nf+2)/2) * W/nf * 0.18u' pd='2*int((nf+1)/2) * (W/nf + 0.18u)'
+ ps='2*int((nf+2)/2) * (W/nf + 0.18u)' nrd='0.18u / W' nrs='0.18u / W' sa=0 sb=0 sd=0 m=1
XMD2 NMD NMD VSS VSS nfet_03v3 L=1u W=2u nf=1 ad='int((nf+1)/2) * W/nf * 0.18u' as='int((nf+2)/2) * W/nf * 0.18u' pd='2*int((nf+1)/2) * (W/nf + 0.18u)'
+ ps='2*int((nf+2)/2) * (W/nf + 0.18u)' nrd='0.18u / W' nrs='0.18u / W' sa=0 sb=0 sd=0 m=1
XMOFF VBP0 VFIX NOFF VSS nfet_03v3 L=1u W=10u nf=1 ad='int((nf+1)/2) * W/nf * 0.18u' as='int((nf+2)/2) * W/nf * 0.18u' pd='2*int((nf+1)/2) * (W/nf + 0.18u)'
+ ps='2*int((nf+2)/2) * (W/nf + 0.18u)' nrd='0.18u / W' nrs='0.18u / W' sa=0 sb=0 sd=0 m=1
XROFF NOFF VSS VSS ppolyf_u_3k r_width=1u r_length=33u m=1
XMVI VBP0 VCTRL NVI VSS nfet_03v3 L=1u W=10u nf=1 ad='int((nf+1)/2) * W/nf * 0.18u' as='int((nf+2)/2) * W/nf * 0.18u' pd='2*int((nf+1)/2) * (W/nf + 0.18u)'
+ ps='2*int((nf+2)/2) * (W/nf + 0.18u)' nrd='0.18u / W' nrs='0.18u / W' sa=0 sb=0 sd=0 m=1
XRDEG NVI VSS VSS ppolyf_u_3k r_width=1u r_length=33u m=1
XMSUM VBP0 VBP0 VDD VDD pfet_03v3 L=1u W=60u nf=4 ad='int((nf+1)/2) * W/nf * 0.18u' as='int((nf+2)/2) * W/nf * 0.18u' pd='2*int((nf+1)/2) * (W/nf + 0.18u)'
+ ps='2*int((nf+2)/2) * (W/nf + 0.18u)' nrd='0.18u / W' nrs='0.18u / W' sa=0 sb=0 sd=0 m=1
XMIP0 B0B B0 VDD VDD pfet_03v3 L=0.28u W=2u nf=1 ad='int((nf+1)/2) * W/nf * 0.18u' as='int((nf+2)/2) * W/nf * 0.18u' pd='2*int((nf+1)/2) * (W/nf + 0.18u)'
+ ps='2*int((nf+2)/2) * (W/nf + 0.18u)' nrd='0.18u / W' nrs='0.18u / W' sa=0 sb=0 sd=0 m=1
XMIN0 B0B B0 VSS VSS nfet_03v3 L=0.28u W=1u nf=1 ad='int((nf+1)/2) * W/nf * 0.18u' as='int((nf+2)/2) * W/nf * 0.18u' pd='2*int((nf+1)/2) * (W/nf + 0.18u)'
+ ps='2*int((nf+2)/2) * (W/nf + 0.18u)' nrd='0.18u / W' nrs='0.18u / W' sa=0 sb=0 sd=0 m=1
XMIP1 B1B B1 VDD VDD pfet_03v3 L=0.28u W=2u nf=1 ad='int((nf+1)/2) * W/nf * 0.18u' as='int((nf+2)/2) * W/nf * 0.18u' pd='2*int((nf+1)/2) * (W/nf + 0.18u)'
+ ps='2*int((nf+2)/2) * (W/nf + 0.18u)' nrd='0.18u / W' nrs='0.18u / W' sa=0 sb=0 sd=0 m=1
XMIN1 B1B B1 VSS VSS nfet_03v3 L=0.28u W=1u nf=1 ad='int((nf+1)/2) * W/nf * 0.18u' as='int((nf+2)/2) * W/nf * 0.18u' pd='2*int((nf+1)/2) * (W/nf + 0.18u)'
+ ps='2*int((nf+2)/2) * (W/nf + 0.18u)' nrd='0.18u / W' nrs='0.18u / W' sa=0 sb=0 sd=0 m=1
XMIP2 B2B B2 VDD VDD pfet_03v3 L=0.28u W=2u nf=1 ad='int((nf+1)/2) * W/nf * 0.18u' as='int((nf+2)/2) * W/nf * 0.18u' pd='2*int((nf+1)/2) * (W/nf + 0.18u)'
+ ps='2*int((nf+2)/2) * (W/nf + 0.18u)' nrd='0.18u / W' nrs='0.18u / W' sa=0 sb=0 sd=0 m=1
XMIN2 B2B B2 VSS VSS nfet_03v3 L=0.28u W=1u nf=1 ad='int((nf+1)/2) * W/nf * 0.18u' as='int((nf+2)/2) * W/nf * 0.18u' pd='2*int((nf+1)/2) * (W/nf + 0.18u)'
+ ps='2*int((nf+2)/2) * (W/nf + 0.18u)' nrd='0.18u / W' nrs='0.18u / W' sa=0 sb=0 sd=0 m=1
XMA0 VBN1 VBP0 VDD VDD pfet_03v3 L=1u W=26.5u nf=2 ad='int((nf+1)/2) * W/nf * 0.18u' as='int((nf+2)/2) * W/nf * 0.18u' pd='2*int((nf+1)/2) * (W/nf + 0.18u)'
+ ps='2*int((nf+2)/2) * (W/nf + 0.18u)' nrd='0.18u / W' nrs='0.18u / W' sa=0 sb=0 sd=0 m=1
XMA1 VBN1 GA VDD VDD pfet_03v3 L=1u W=17.225u nf=2 ad='int((nf+1)/2) * W/nf * 0.18u' as='int((nf+2)/2) * W/nf * 0.18u' pd='2*int((nf+1)/2) * (W/nf + 0.18u)'
+ ps='2*int((nf+2)/2) * (W/nf + 0.18u)' nrd='0.18u / W' nrs='0.18u / W' sa=0 sb=0 sd=0 m=1
XMSWA0 GA B0B VBP0 VDD pfet_03v3 L=0.5u W=2u nf=1 ad='int((nf+1)/2) * W/nf * 0.18u' as='int((nf+2)/2) * W/nf * 0.18u' pd='2*int((nf+1)/2) * (W/nf + 0.18u)'
+ ps='2*int((nf+2)/2) * (W/nf + 0.18u)' nrd='0.18u / W' nrs='0.18u / W' sa=0 sb=0 sd=0 m=1
XMSWA1 GA B0 VDD VDD pfet_03v3 L=0.5u W=2u nf=1 ad='int((nf+1)/2) * W/nf * 0.18u' as='int((nf+2)/2) * W/nf * 0.18u' pd='2*int((nf+1)/2) * (W/nf + 0.18u)'
+ ps='2*int((nf+2)/2) * (W/nf + 0.18u)' nrd='0.18u / W' nrs='0.18u / W' sa=0 sb=0 sd=0 m=1
XMDA VBN1 VBN1 VSS VSS nfet_03v3 L=1u W=10u nf=1 ad='int((nf+1)/2) * W/nf * 0.18u' as='int((nf+2)/2) * W/nf * 0.18u' pd='2*int((nf+1)/2) * (W/nf + 0.18u)'
+ ps='2*int((nf+2)/2) * (W/nf + 0.18u)' nrd='0.18u / W' nrs='0.18u / W' sa=0 sb=0 sd=0 m=1
XMB0 VBP2 VBN1 VSS VSS nfet_03v3 L=1u W=5u nf=1 ad='int((nf+1)/2) * W/nf * 0.18u' as='int((nf+2)/2) * W/nf * 0.18u' pd='2*int((nf+1)/2) * (W/nf + 0.18u)'
+ ps='2*int((nf+2)/2) * (W/nf + 0.18u)' nrd='0.18u / W' nrs='0.18u / W' sa=0 sb=0 sd=0 m=1
XMB1 VBP2 GB VSS VSS nfet_03v3 L=1u W=8.6125u nf=1 ad='int((nf+1)/2) * W/nf * 0.18u' as='int((nf+2)/2) * W/nf * 0.18u' pd='2*int((nf+1)/2) * (W/nf + 0.18u)'
+ ps='2*int((nf+2)/2) * (W/nf + 0.18u)' nrd='0.18u / W' nrs='0.18u / W' sa=0 sb=0 sd=0 m=1
XMSWB0 GB B1 VBN1 VSS nfet_03v3 L=0.5u W=2u nf=1 ad='int((nf+1)/2) * W/nf * 0.18u' as='int((nf+2)/2) * W/nf * 0.18u' pd='2*int((nf+1)/2) * (W/nf + 0.18u)'
+ ps='2*int((nf+2)/2) * (W/nf + 0.18u)' nrd='0.18u / W' nrs='0.18u / W' sa=0 sb=0 sd=0 m=1
XMSWB1 GB B1B VSS VSS nfet_03v3 L=0.5u W=2u nf=1 ad='int((nf+1)/2) * W/nf * 0.18u' as='int((nf+2)/2) * W/nf * 0.18u' pd='2*int((nf+1)/2) * (W/nf + 0.18u)'
+ ps='2*int((nf+2)/2) * (W/nf + 0.18u)' nrd='0.18u / W' nrs='0.18u / W' sa=0 sb=0 sd=0 m=1
XMDB VBP2 VBP2 VDD VDD pfet_03v3 L=1u W=20u nf=1 ad='int((nf+1)/2) * W/nf * 0.18u' as='int((nf+2)/2) * W/nf * 0.18u' pd='2*int((nf+1)/2) * (W/nf + 0.18u)'
+ ps='2*int((nf+2)/2) * (W/nf + 0.18u)' nrd='0.18u / W' nrs='0.18u / W' sa=0 sb=0 sd=0 m=1
XMC0 VBN VBP2 VDD VDD pfet_03v3 L=1u W=12.3u nf=1 ad='int((nf+1)/2) * W/nf * 0.18u' as='int((nf+2)/2) * W/nf * 0.18u' pd='2*int((nf+1)/2) * (W/nf + 0.18u)'
+ ps='2*int((nf+2)/2) * (W/nf + 0.18u)' nrd='0.18u / W' nrs='0.18u / W' sa=0 sb=0 sd=0 m=1
XMC1 VBN GC VDD VDD pfet_03v3 L=1u W=78.87u nf=8 ad='int((nf+1)/2) * W/nf * 0.18u' as='int((nf+2)/2) * W/nf * 0.18u' pd='2*int((nf+1)/2) * (W/nf + 0.18u)'
+ ps='2*int((nf+2)/2) * (W/nf + 0.18u)' nrd='0.18u / W' nrs='0.18u / W' sa=0 sb=0 sd=0 m=1
XMSWC0 GC B2B VBP2 VDD pfet_03v3 L=0.5u W=2u nf=1 ad='int((nf+1)/2) * W/nf * 0.18u' as='int((nf+2)/2) * W/nf * 0.18u' pd='2*int((nf+1)/2) * (W/nf + 0.18u)'
+ ps='2*int((nf+2)/2) * (W/nf + 0.18u)' nrd='0.18u / W' nrs='0.18u / W' sa=0 sb=0 sd=0 m=1
XMSWC1 GC B2 VDD VDD pfet_03v3 L=0.5u W=2u nf=1 ad='int((nf+1)/2) * W/nf * 0.18u' as='int((nf+2)/2) * W/nf * 0.18u' pd='2*int((nf+1)/2) * (W/nf + 0.18u)'
+ ps='2*int((nf+2)/2) * (W/nf + 0.18u)' nrd='0.18u / W' nrs='0.18u / W' sa=0 sb=0 sd=0 m=1
XMDN VBN VBN VSS VSS nfet_03v3 L=0.5u W=4u nf=1 ad='int((nf+1)/2) * W/nf * 0.18u' as='int((nf+2)/2) * W/nf * 0.18u' pd='2*int((nf+1)/2) * (W/nf + 0.18u)'
+ ps='2*int((nf+2)/2) * (W/nf + 0.18u)' nrd='0.18u / W' nrs='0.18u / W' sa=0 sb=0 sd=0 m=1
XMMN VBP VBN VSS VSS nfet_03v3 L=0.5u W=4u nf=1 ad='int((nf+1)/2) * W/nf * 0.18u' as='int((nf+2)/2) * W/nf * 0.18u' pd='2*int((nf+1)/2) * (W/nf + 0.18u)'
+ ps='2*int((nf+2)/2) * (W/nf + 0.18u)' nrd='0.18u / W' nrs='0.18u / W' sa=0 sb=0 sd=0 m=1
XMDP VBP VBP VDD VDD pfet_03v3 L=0.5u W=10u nf=1 ad='int((nf+1)/2) * W/nf * 0.18u' as='int((nf+2)/2) * W/nf * 0.18u' pd='2*int((nf+1)/2) * (W/nf + 0.18u)'
+ ps='2*int((nf+2)/2) * (W/nf + 0.18u)' nrd='0.18u / W' nrs='0.18u / W' sa=0 sb=0 sd=0 m=1
.ends

* expanding   symbol:  vco_stage.sym # of pins=6
** sym_path: design/vco_stage.sym
** sch_path: design/vco_stage.sch
.subckt vco_stage A Y VDD VSS VBP VBN
*.ipin A
*.opin Y
*.iopin VDD
*.iopin VSS
*.iopin VBP
*.iopin VBN
XMPH NH VBP VDD VDD pfet_03v3 L=0.5u W=10u nf=1 ad='int((nf+1)/2) * W/nf * 0.18u' as='int((nf+2)/2) * W/nf * 0.18u' pd='2*int((nf+1)/2) * (W/nf + 0.18u)'
+ ps='2*int((nf+2)/2) * (W/nf + 0.18u)' nrd='0.18u / W' nrs='0.18u / W' sa=0 sb=0 sd=0 m=1
XMP Y A NH VDD pfet_03v3 L=0.28u W=5u nf=1 ad='int((nf+1)/2) * W/nf * 0.18u' as='int((nf+2)/2) * W/nf * 0.18u' pd='2*int((nf+1)/2) * (W/nf + 0.18u)'
+ ps='2*int((nf+2)/2) * (W/nf + 0.18u)' nrd='0.18u / W' nrs='0.18u / W' sa=0 sb=0 sd=0 m=1
XMN Y A NT VSS nfet_03v3 L=0.28u W=2u nf=1 ad='int((nf+1)/2) * W/nf * 0.18u' as='int((nf+2)/2) * W/nf * 0.18u' pd='2*int((nf+1)/2) * (W/nf + 0.18u)'
+ ps='2*int((nf+2)/2) * (W/nf + 0.18u)' nrd='0.18u / W' nrs='0.18u / W' sa=0 sb=0 sd=0 m=1
XMNT NT VBN VSS VSS nfet_03v3 L=0.5u W=4u nf=1 ad='int((nf+1)/2) * W/nf * 0.18u' as='int((nf+2)/2) * W/nf * 0.18u' pd='2*int((nf+1)/2) * (W/nf + 0.18u)'
+ ps='2*int((nf+2)/2) * (W/nf + 0.18u)' nrd='0.18u / W' nrs='0.18u / W' sa=0 sb=0 sd=0 m=1
.ends

* expanding   symbol:  div23_cell.sym # of pins=7
** sym_path: design/div23_cell.sym
** sch_path: design/div23_cell.sch
.subckt div23_cell CKIN MODIN P CKOUT MODOUT VDD VSS
*.ipin CKIN
*.ipin MODIN
*.ipin P
*.opin CKOUT
*.opin MODOUT
*.iopin VDD
*.iopin VSS
XN3 MODIN P MODOUT SB VDD VSS nand3_3v3
XN2Q QB SB DQN VDD VSS nand2_3v3
XIQ DQN DQ VDD VSS inv_3v3
XFQ DQ CKIN Q QB VDD VSS dff_tg_3v3
XICKO QB CKOUT VDD VSS inv2x_3v3
XN2M MODIN Q NMO VDD VSS nand2_3v3
XIM NMO DMO VDD VSS inv_3v3
XFMO DMO CKIN MODOUT MOB VDD VSS dff_tg_3v3
.ends

* expanding   symbol:  nor2_3v3.sym # of pins=5
** sym_path: design/nor2_3v3.sym
** sch_path: design/nor2_3v3.sch
.subckt nor2_3v3 A B Y VDD VSS
*.ipin A
*.ipin B
*.opin Y
*.iopin VDD
*.iopin VSS
XMPA PMID A VDD VDD pfet_03v3 L=0.28u W=5u nf=1 ad='int((nf+1)/2) * W/nf * 0.18u' as='int((nf+2)/2) * W/nf * 0.18u' pd='2*int((nf+1)/2) * (W/nf + 0.18u)'
+ ps='2*int((nf+2)/2) * (W/nf + 0.18u)' nrd='0.18u / W' nrs='0.18u / W' sa=0 sb=0 sd=0 m=1
XMPB Y B PMID VDD pfet_03v3 L=0.28u W=5u nf=1 ad='int((nf+1)/2) * W/nf * 0.18u' as='int((nf+2)/2) * W/nf * 0.18u' pd='2*int((nf+1)/2) * (W/nf + 0.18u)'
+ ps='2*int((nf+2)/2) * (W/nf + 0.18u)' nrd='0.18u / W' nrs='0.18u / W' sa=0 sb=0 sd=0 m=1
XMNA Y A VSS VSS nfet_03v3 L=0.28u W=1u nf=1 ad='int((nf+1)/2) * W/nf * 0.18u' as='int((nf+2)/2) * W/nf * 0.18u' pd='2*int((nf+1)/2) * (W/nf + 0.18u)'
+ ps='2*int((nf+2)/2) * (W/nf + 0.18u)' nrd='0.18u / W' nrs='0.18u / W' sa=0 sb=0 sd=0 m=1
XMNB Y B VSS VSS nfet_03v3 L=0.28u W=1u nf=1 ad='int((nf+1)/2) * W/nf * 0.18u' as='int((nf+2)/2) * W/nf * 0.18u' pd='2*int((nf+1)/2) * (W/nf + 0.18u)'
+ ps='2*int((nf+2)/2) * (W/nf + 0.18u)' nrd='0.18u / W' nrs='0.18u / W' sa=0 sb=0 sd=0 m=1
.ends

* expanding   symbol:  inv_3v3.sym # of pins=4
** sym_path: design/inv_3v3.sym
** sch_path: design/inv_3v3.sch
.subckt inv_3v3 A Y VDD VSS
*.ipin A
*.opin Y
*.iopin VDD
*.iopin VSS
XMP Y A VDD VDD pfet_03v3 L=0.28u W=2.5u nf=1 ad='int((nf+1)/2) * W/nf * 0.18u' as='int((nf+2)/2) * W/nf * 0.18u' pd='2*int((nf+1)/2) * (W/nf + 0.18u)'
+ ps='2*int((nf+2)/2) * (W/nf + 0.18u)' nrd='0.18u / W' nrs='0.18u / W' sa=0 sb=0 sd=0 m=1
XMN Y A VSS VSS nfet_03v3 L=0.28u W=1u nf=1 ad='int((nf+1)/2) * W/nf * 0.18u' as='int((nf+2)/2) * W/nf * 0.18u' pd='2*int((nf+1)/2) * (W/nf + 0.18u)'
+ ps='2*int((nf+2)/2) * (W/nf + 0.18u)' nrd='0.18u / W' nrs='0.18u / W' sa=0 sb=0 sd=0 m=1
.ends

* expanding   symbol:  nand2_3v3.sym # of pins=5
** sym_path: design/nand2_3v3.sym
** sch_path: design/nand2_3v3.sch
.subckt nand2_3v3 A B Y VDD VSS
*.ipin A
*.ipin B
*.opin Y
*.iopin VDD
*.iopin VSS
XMPA Y A VDD VDD pfet_03v3 L=0.28u W=2.5u nf=1 ad='int((nf+1)/2) * W/nf * 0.18u' as='int((nf+2)/2) * W/nf * 0.18u' pd='2*int((nf+1)/2) * (W/nf + 0.18u)'
+ ps='2*int((nf+2)/2) * (W/nf + 0.18u)' nrd='0.18u / W' nrs='0.18u / W' sa=0 sb=0 sd=0 m=1
XMPB Y B VDD VDD pfet_03v3 L=0.28u W=2.5u nf=1 ad='int((nf+1)/2) * W/nf * 0.18u' as='int((nf+2)/2) * W/nf * 0.18u' pd='2*int((nf+1)/2) * (W/nf + 0.18u)'
+ ps='2*int((nf+2)/2) * (W/nf + 0.18u)' nrd='0.18u / W' nrs='0.18u / W' sa=0 sb=0 sd=0 m=1
XMNA Y A NMID VSS nfet_03v3 L=0.28u W=2u nf=1 ad='int((nf+1)/2) * W/nf * 0.18u' as='int((nf+2)/2) * W/nf * 0.18u' pd='2*int((nf+1)/2) * (W/nf + 0.18u)'
+ ps='2*int((nf+2)/2) * (W/nf + 0.18u)' nrd='0.18u / W' nrs='0.18u / W' sa=0 sb=0 sd=0 m=1
XMNB NMID B VSS VSS nfet_03v3 L=0.28u W=2u nf=1 ad='int((nf+1)/2) * W/nf * 0.18u' as='int((nf+2)/2) * W/nf * 0.18u' pd='2*int((nf+1)/2) * (W/nf + 0.18u)'
+ ps='2*int((nf+2)/2) * (W/nf + 0.18u)' nrd='0.18u / W' nrs='0.18u / W' sa=0 sb=0 sd=0 m=1
.ends

* expanding   symbol:  nand3_3v3.sym # of pins=6
** sym_path: design/nand3_3v3.sym
** sch_path: design/nand3_3v3.sch
.subckt nand3_3v3 A B C Y VDD VSS
*.ipin A
*.ipin B
*.ipin C
*.opin Y
*.iopin VDD
*.iopin VSS
XMPA Y A VDD VDD pfet_03v3 L=0.28u W=2.5u nf=1 ad='int((nf+1)/2) * W/nf * 0.18u' as='int((nf+2)/2) * W/nf * 0.18u' pd='2*int((nf+1)/2) * (W/nf + 0.18u)'
+ ps='2*int((nf+2)/2) * (W/nf + 0.18u)' nrd='0.18u / W' nrs='0.18u / W' sa=0 sb=0 sd=0 m=1
XMPB Y B VDD VDD pfet_03v3 L=0.28u W=2.5u nf=1 ad='int((nf+1)/2) * W/nf * 0.18u' as='int((nf+2)/2) * W/nf * 0.18u' pd='2*int((nf+1)/2) * (W/nf + 0.18u)'
+ ps='2*int((nf+2)/2) * (W/nf + 0.18u)' nrd='0.18u / W' nrs='0.18u / W' sa=0 sb=0 sd=0 m=1
XMPC Y C VDD VDD pfet_03v3 L=0.28u W=2.5u nf=1 ad='int((nf+1)/2) * W/nf * 0.18u' as='int((nf+2)/2) * W/nf * 0.18u' pd='2*int((nf+1)/2) * (W/nf + 0.18u)'
+ ps='2*int((nf+2)/2) * (W/nf + 0.18u)' nrd='0.18u / W' nrs='0.18u / W' sa=0 sb=0 sd=0 m=1
XMNA Y A NM1 VSS nfet_03v3 L=0.28u W=3u nf=1 ad='int((nf+1)/2) * W/nf * 0.18u' as='int((nf+2)/2) * W/nf * 0.18u' pd='2*int((nf+1)/2) * (W/nf + 0.18u)'
+ ps='2*int((nf+2)/2) * (W/nf + 0.18u)' nrd='0.18u / W' nrs='0.18u / W' sa=0 sb=0 sd=0 m=1
XMNB NM1 B NM2 VSS nfet_03v3 L=0.28u W=3u nf=1 ad='int((nf+1)/2) * W/nf * 0.18u' as='int((nf+2)/2) * W/nf * 0.18u' pd='2*int((nf+1)/2) * (W/nf + 0.18u)'
+ ps='2*int((nf+2)/2) * (W/nf + 0.18u)' nrd='0.18u / W' nrs='0.18u / W' sa=0 sb=0 sd=0 m=1
XMNC NM2 C VSS VSS nfet_03v3 L=0.28u W=3u nf=1 ad='int((nf+1)/2) * W/nf * 0.18u' as='int((nf+2)/2) * W/nf * 0.18u' pd='2*int((nf+1)/2) * (W/nf + 0.18u)'
+ ps='2*int((nf+2)/2) * (W/nf + 0.18u)' nrd='0.18u / W' nrs='0.18u / W' sa=0 sb=0 sd=0 m=1
.ends

* expanding   symbol:  inv2x_3v3.sym # of pins=4
** sym_path: design/inv2x_3v3.sym
** sch_path: design/inv2x_3v3.sch
.subckt inv2x_3v3 A Y VDD VSS
*.ipin A
*.opin Y
*.iopin VDD
*.iopin VSS
XMP Y A VDD VDD pfet_03v3 L=0.28u W=5u nf=1 ad='int((nf+1)/2) * W/nf * 0.18u' as='int((nf+2)/2) * W/nf * 0.18u' pd='2*int((nf+1)/2) * (W/nf + 0.18u)'
+ ps='2*int((nf+2)/2) * (W/nf + 0.18u)' nrd='0.18u / W' nrs='0.18u / W' sa=0 sb=0 sd=0 m=1
XMN Y A VSS VSS nfet_03v3 L=0.28u W=2u nf=1 ad='int((nf+1)/2) * W/nf * 0.18u' as='int((nf+2)/2) * W/nf * 0.18u' pd='2*int((nf+1)/2) * (W/nf + 0.18u)'
+ ps='2*int((nf+2)/2) * (W/nf + 0.18u)' nrd='0.18u / W' nrs='0.18u / W' sa=0 sb=0 sd=0 m=1
.ends

* expanding   symbol:  dff_tg_3v3.sym # of pins=6
** sym_path: design/dff_tg_3v3.sym
** sch_path: design/dff_tg_3v3.sch
.subckt dff_tg_3v3 D CK Q QB VDD VSS
*.ipin D
*.ipin CK
*.opin Q
*.opin QB
*.iopin VDD
*.iopin VSS
XICKB CK CKB VDD VSS inv_3v3
XICKBB CKB CKBB VDD VSS inv_3v3
XTGMI D NM CKB CKBB VDD VSS tgate_3v3
XIA NM NMA VDD VSS inv_3v3
XIB NMA NMB VDD VSS inv_3v3
XTGMF NMB NM CKBB CKB VDD VSS tgate_3v3
XTGSI NMA NS CKBB CKB VDD VSS tgate_3v3
XIC NS Q VDD VSS inv_3v3
XID Q QB VDD VSS inv_3v3
XTGSF QB NS CKB CKBB VDD VSS tgate_3v3
.ends

* expanding   symbol:  xor2_3v3.sym # of pins=5
** sym_path: design/xor2_3v3.sym
** sch_path: design/xor2_3v3.sch
.subckt xor2_3v3 A B Y VDD VSS
*.ipin A
*.ipin B
*.opin Y
*.iopin VDD
*.iopin VSS
XG1 A B N1 VDD VSS nand2_3v3
XG2 A N1 N2 VDD VSS nand2_3v3
XG3 B N1 N3 VDD VSS nand2_3v3
XG4 N2 N3 Y VDD VSS nand2_3v3
.ends

* expanding   symbol:  delaywin_3v3.sym # of pins=4
** sym_path: design/delaywin_3v3.sym
** sch_path: design/delaywin_3v3.sch
.subckt delaywin_3v3 A Y VDD VSS
*.ipin A
*.opin Y
*.iopin VDD
*.iopin VSS
XI1 A D1 VDD VSS inv_3v3
XMC1 VSS D1 VSS VSS nfet_03v3 L=2u W=8u nf=1 ad='int((nf+1)/2) * W/nf * 0.18u' as='int((nf+2)/2) * W/nf * 0.18u' pd='2*int((nf+1)/2) * (W/nf + 0.18u)'
+ ps='2*int((nf+2)/2) * (W/nf + 0.18u)' nrd='0.18u / W' nrs='0.18u / W' sa=0 sb=0 sd=0 m=1
XI2 D1 D2 VDD VSS inv_3v3
XMC2 VSS D2 VSS VSS nfet_03v3 L=2u W=8u nf=1 ad='int((nf+1)/2) * W/nf * 0.18u' as='int((nf+2)/2) * W/nf * 0.18u' pd='2*int((nf+1)/2) * (W/nf + 0.18u)'
+ ps='2*int((nf+2)/2) * (W/nf + 0.18u)' nrd='0.18u / W' nrs='0.18u / W' sa=0 sb=0 sd=0 m=1
XI3 D2 D3 VDD VSS inv_3v3
XMC3 VSS D3 VSS VSS nfet_03v3 L=2u W=8u nf=1 ad='int((nf+1)/2) * W/nf * 0.18u' as='int((nf+2)/2) * W/nf * 0.18u' pd='2*int((nf+1)/2) * (W/nf + 0.18u)'
+ ps='2*int((nf+2)/2) * (W/nf + 0.18u)' nrd='0.18u / W' nrs='0.18u / W' sa=0 sb=0 sd=0 m=1
XI4 D3 Y VDD VSS inv_3v3
XMC4 VSS Y VSS VSS nfet_03v3 L=2u W=8u nf=1 ad='int((nf+1)/2) * W/nf * 0.18u' as='int((nf+2)/2) * W/nf * 0.18u' pd='2*int((nf+1)/2) * (W/nf + 0.18u)'
+ ps='2*int((nf+2)/2) * (W/nf + 0.18u)' nrd='0.18u / W' nrs='0.18u / W' sa=0 sb=0 sd=0 m=1
.ends

* expanding   symbol:  schmitt_3v3.sym # of pins=4
** sym_path: design/schmitt_3v3.sym
** sch_path: design/schmitt_3v3.sch
.subckt schmitt_3v3 A Y VDD VSS
*.ipin A
*.opin Y
*.iopin VDD
*.iopin VSS
XMP1 P1 A VDD VDD pfet_03v3 L=0.28u W=2.5u nf=1 ad='int((nf+1)/2) * W/nf * 0.18u' as='int((nf+2)/2) * W/nf * 0.18u' pd='2*int((nf+1)/2) * (W/nf + 0.18u)'
+ ps='2*int((nf+2)/2) * (W/nf + 0.18u)' nrd='0.18u / W' nrs='0.18u / W' sa=0 sb=0 sd=0 m=1
XMP2 Y A P1 VDD pfet_03v3 L=0.28u W=2.5u nf=1 ad='int((nf+1)/2) * W/nf * 0.18u' as='int((nf+2)/2) * W/nf * 0.18u' pd='2*int((nf+1)/2) * (W/nf + 0.18u)'
+ ps='2*int((nf+2)/2) * (W/nf + 0.18u)' nrd='0.18u / W' nrs='0.18u / W' sa=0 sb=0 sd=0 m=1
XMP3 VSS Y P1 VDD pfet_03v3 L=0.28u W=1.2u nf=1 ad='int((nf+1)/2) * W/nf * 0.18u' as='int((nf+2)/2) * W/nf * 0.18u' pd='2*int((nf+1)/2) * (W/nf + 0.18u)'
+ ps='2*int((nf+2)/2) * (W/nf + 0.18u)' nrd='0.18u / W' nrs='0.18u / W' sa=0 sb=0 sd=0 m=1
XMN1 N1 A VSS VSS nfet_03v3 L=0.28u W=1u nf=1 ad='int((nf+1)/2) * W/nf * 0.18u' as='int((nf+2)/2) * W/nf * 0.18u' pd='2*int((nf+1)/2) * (W/nf + 0.18u)'
+ ps='2*int((nf+2)/2) * (W/nf + 0.18u)' nrd='0.18u / W' nrs='0.18u / W' sa=0 sb=0 sd=0 m=1
XMN2 Y A N1 VSS nfet_03v3 L=0.28u W=1u nf=1 ad='int((nf+1)/2) * W/nf * 0.18u' as='int((nf+2)/2) * W/nf * 0.18u' pd='2*int((nf+1)/2) * (W/nf + 0.18u)'
+ ps='2*int((nf+2)/2) * (W/nf + 0.18u)' nrd='0.18u / W' nrs='0.18u / W' sa=0 sb=0 sd=0 m=1
XMN3 VDD Y N1 VSS nfet_03v3 L=0.28u W=0.5u nf=1 ad='int((nf+1)/2) * W/nf * 0.18u' as='int((nf+2)/2) * W/nf * 0.18u' pd='2*int((nf+1)/2) * (W/nf + 0.18u)'
+ ps='2*int((nf+2)/2) * (W/nf + 0.18u)' nrd='0.18u / W' nrs='0.18u / W' sa=0 sb=0 sd=0 m=1
.ends

* expanding   symbol:  edgedet.sym # of pins=4
** sym_path: design/edgedet.sym
** sch_path: design/edgedet.sch
.subckt edgedet X PULSE VDD VSS
*.ipin X
*.opin PULSE
*.iopin VDD
*.iopin VSS
xi1 X D1 VDD VSS pfdcp_inv_3v3
xi2 D1 D2 VDD VSS pfdcp_inv_3v3
xi3 D2 D3 VDD VSS pfdcp_inv_3v3
xi4 D3 D4 VDD VSS pfdcp_inv_3v3
xi5 D4 D5 VDD VSS pfdcp_inv_3v3
xnd X D5 NN VDD VSS pfdcp_nand2_3v3
xi6 NN PULSE VDD VSS pfdcp_inv_3v3
.ends

* expanding   symbol:  pfdcp_inv_3v3.sym # of pins=4
** sym_path: design/pfdcp_inv_3v3.sym
** sch_path: design/pfdcp_inv_3v3.sch
.subckt pfdcp_inv_3v3 A Y VDD VSS
*.ipin A
*.opin Y
*.iopin VDD
*.iopin VSS
XMP Y A VDD VDD pfet_03v3 L=0.3u W=1.5u nf=1 ad='int((nf+1)/2) * W/nf * 0.18u' as='int((nf+2)/2) * W/nf * 0.18u' pd='2*int((nf+1)/2) * (W/nf + 0.18u)'
+ ps='2*int((nf+2)/2) * (W/nf + 0.18u)' nrd='0.18u / W' nrs='0.18u / W' sa=0 sb=0 sd=0 m=1
XMN Y A VSS VSS nfet_03v3 L=0.3u W=0.5u nf=1 ad='int((nf+1)/2) * W/nf * 0.18u' as='int((nf+2)/2) * W/nf * 0.18u' pd='2*int((nf+1)/2) * (W/nf + 0.18u)'
+ ps='2*int((nf+2)/2) * (W/nf + 0.18u)' nrd='0.18u / W' nrs='0.18u / W' sa=0 sb=0 sd=0 m=1
.ends

* expanding   symbol:  srlatch.sym # of pins=6
** sym_path: design/srlatch.sym
** sch_path: design/srlatch.sch
.subckt srlatch SB RB Q QB VDD VSS
*.ipin SB
*.ipin RB
*.opin Q
*.opin QB
*.iopin VDD
*.iopin VSS
xn1 SB QB Q VDD VSS pfdcp_nand2_3v3
xn2 RB Q QB VDD VSS pfdcp_nand2_3v3
.ends

* expanding   symbol:  pfdcp_nand2_3v3.sym # of pins=5
** sym_path: design/pfdcp_nand2_3v3.sym
** sch_path: design/pfdcp_nand2_3v3.sch
.subckt pfdcp_nand2_3v3 A B Y VDD VSS
*.ipin A
*.ipin B
*.opin Y
*.iopin VDD
*.iopin VSS
XMP1 Y A VDD VDD pfet_03v3 L=0.3u W=1.5u nf=1 ad='int((nf+1)/2) * W/nf * 0.18u' as='int((nf+2)/2) * W/nf * 0.18u' pd='2*int((nf+1)/2) * (W/nf + 0.18u)'
+ ps='2*int((nf+2)/2) * (W/nf + 0.18u)' nrd='0.18u / W' nrs='0.18u / W' sa=0 sb=0 sd=0 m=1
XMP2 Y B VDD VDD pfet_03v3 L=0.3u W=1.5u nf=1 ad='int((nf+1)/2) * W/nf * 0.18u' as='int((nf+2)/2) * W/nf * 0.18u' pd='2*int((nf+1)/2) * (W/nf + 0.18u)'
+ ps='2*int((nf+2)/2) * (W/nf + 0.18u)' nrd='0.18u / W' nrs='0.18u / W' sa=0 sb=0 sd=0 m=1
XMN1 Y A NI VSS nfet_03v3 L=0.3u W=1u nf=1 ad='int((nf+1)/2) * W/nf * 0.18u' as='int((nf+2)/2) * W/nf * 0.18u' pd='2*int((nf+1)/2) * (W/nf + 0.18u)'
+ ps='2*int((nf+2)/2) * (W/nf + 0.18u)' nrd='0.18u / W' nrs='0.18u / W' sa=0 sb=0 sd=0 m=1
XMN2 NI B VSS VSS nfet_03v3 L=0.3u W=1u nf=1 ad='int((nf+1)/2) * W/nf * 0.18u' as='int((nf+2)/2) * W/nf * 0.18u' pd='2*int((nf+1)/2) * (W/nf + 0.18u)'
+ ps='2*int((nf+2)/2) * (W/nf + 0.18u)' nrd='0.18u / W' nrs='0.18u / W' sa=0 sb=0 sd=0 m=1
.ends

* expanding   symbol:  cp_leg_n.sym # of pins=6
** sym_path: design/cp_leg_n.sym
** sch_path: design/cp_leg_n.sch
.subckt cp_leg_n VBN VCASCN EN ENB TAIL VSS
*.ipin VBN
*.ipin VCASCN
*.ipin EN
*.ipin ENB
*.iopin TAIL
*.iopin VSS
XMEN BG EN VBN VSS nfet_03v3 L=0.3u W=1u nf=1 ad='int((nf+1)/2) * W/nf * 0.18u' as='int((nf+2)/2) * W/nf * 0.18u' pd='2*int((nf+1)/2) * (W/nf + 0.18u)'
+ ps='2*int((nf+2)/2) * (W/nf + 0.18u)' nrd='0.18u / W' nrs='0.18u / W' sa=0 sb=0 sd=0 m=1
XMDIS BG ENB VSS VSS nfet_03v3 L=0.3u W=1u nf=1 ad='int((nf+1)/2) * W/nf * 0.18u' as='int((nf+2)/2) * W/nf * 0.18u' pd='2*int((nf+1)/2) * (W/nf + 0.18u)'
+ ps='2*int((nf+2)/2) * (W/nf + 0.18u)' nrd='0.18u / W' nrs='0.18u / W' sa=0 sb=0 sd=0 m=1
XMBOT MID BG VSS VSS nfet_03v3 L=1u W=4u nf=1 ad='int((nf+1)/2) * W/nf * 0.18u' as='int((nf+2)/2) * W/nf * 0.18u' pd='2*int((nf+1)/2) * (W/nf + 0.18u)'
+ ps='2*int((nf+2)/2) * (W/nf + 0.18u)' nrd='0.18u / W' nrs='0.18u / W' sa=0 sb=0 sd=0 m=1
XMCASC TAIL VCASCN MID VSS nfet_03v3 L=1u W=4u nf=1 ad='int((nf+1)/2) * W/nf * 0.18u' as='int((nf+2)/2) * W/nf * 0.18u' pd='2*int((nf+1)/2) * (W/nf + 0.18u)'
+ ps='2*int((nf+2)/2) * (W/nf + 0.18u)' nrd='0.18u / W' nrs='0.18u / W' sa=0 sb=0 sd=0 m=1
.ends

* expanding   symbol:  cp_leg_p.sym # of pins=6
** sym_path: design/cp_leg_p.sym
** sch_path: design/cp_leg_p.sch
.subckt cp_leg_p VBP VCASCP EN ENB TAIL VDD
*.ipin VBP
*.ipin VCASCP
*.ipin EN
*.ipin ENB
*.iopin TAIL
*.iopin VDD
XMEN BG ENB VBP VDD pfet_03v3 L=0.3u W=1u nf=1 ad='int((nf+1)/2) * W/nf * 0.18u' as='int((nf+2)/2) * W/nf * 0.18u' pd='2*int((nf+1)/2) * (W/nf + 0.18u)'
+ ps='2*int((nf+2)/2) * (W/nf + 0.18u)' nrd='0.18u / W' nrs='0.18u / W' sa=0 sb=0 sd=0 m=1
XMDIS BG EN VDD VDD pfet_03v3 L=0.3u W=1u nf=1 ad='int((nf+1)/2) * W/nf * 0.18u' as='int((nf+2)/2) * W/nf * 0.18u' pd='2*int((nf+1)/2) * (W/nf + 0.18u)'
+ ps='2*int((nf+2)/2) * (W/nf + 0.18u)' nrd='0.18u / W' nrs='0.18u / W' sa=0 sb=0 sd=0 m=1
XMTOP MID BG VDD VDD pfet_03v3 L=1u W=12u nf=1 ad='int((nf+1)/2) * W/nf * 0.18u' as='int((nf+2)/2) * W/nf * 0.18u' pd='2*int((nf+1)/2) * (W/nf + 0.18u)'
+ ps='2*int((nf+2)/2) * (W/nf + 0.18u)' nrd='0.18u / W' nrs='0.18u / W' sa=0 sb=0 sd=0 m=1
XMCASC TAIL VCASCP MID VDD pfet_03v3 L=1u W=12u nf=1 ad='int((nf+1)/2) * W/nf * 0.18u' as='int((nf+2)/2) * W/nf * 0.18u' pd='2*int((nf+1)/2) * (W/nf + 0.18u)'
+ ps='2*int((nf+2)/2) * (W/nf + 0.18u)' nrd='0.18u / W' nrs='0.18u / W' sa=0 sb=0 sd=0 m=1
.ends

* expanding   symbol:  cp_dumpbuf.sym # of pins=6
** sym_path: design/cp_dumpbuf.sym
** sch_path: design/cp_dumpbuf.sch
.subckt cp_dumpbuf VREF VBN VBP VDUMP VDD VSS
*.ipin VREF
*.ipin VBN
*.ipin VBP
*.iopin VDUMP
*.iopin VDD
*.iopin VSS
XMTN NSRC VBN VSS VSS nfet_03v3 L=1u W=16u nf=1 ad='int((nf+1)/2) * W/nf * 0.18u' as='int((nf+2)/2) * W/nf * 0.18u' pd='2*int((nf+1)/2) * (W/nf + 0.18u)'
+ ps='2*int((nf+2)/2) * (W/nf + 0.18u)' nrd='0.18u / W' nrs='0.18u / W' sa=0 sb=0 sd=0 m=1
XMN1 NDA VREF NSRC VSS nfet_03v3 L=1u W=16u nf=1 ad='int((nf+1)/2) * W/nf * 0.18u' as='int((nf+2)/2) * W/nf * 0.18u' pd='2*int((nf+1)/2) * (W/nf + 0.18u)'
+ ps='2*int((nf+2)/2) * (W/nf + 0.18u)' nrd='0.18u / W' nrs='0.18u / W' sa=0 sb=0 sd=0 m=1
XMN2 VDUMP VDUMP NSRC VSS nfet_03v3 L=1u W=16u nf=1 ad='int((nf+1)/2) * W/nf * 0.18u' as='int((nf+2)/2) * W/nf * 0.18u' pd='2*int((nf+1)/2) * (W/nf + 0.18u)'
+ ps='2*int((nf+2)/2) * (W/nf + 0.18u)' nrd='0.18u / W' nrs='0.18u / W' sa=0 sb=0 sd=0 m=1
XMN3 NDA NDA VDD VDD pfet_03v3 L=1u W=24u nf=1 ad='int((nf+1)/2) * W/nf * 0.18u' as='int((nf+2)/2) * W/nf * 0.18u' pd='2*int((nf+1)/2) * (W/nf + 0.18u)'
+ ps='2*int((nf+2)/2) * (W/nf + 0.18u)' nrd='0.18u / W' nrs='0.18u / W' sa=0 sb=0 sd=0 m=1
XMN4 VDUMP NDA VDD VDD pfet_03v3 L=1u W=24u nf=1 ad='int((nf+1)/2) * W/nf * 0.18u' as='int((nf+2)/2) * W/nf * 0.18u' pd='2*int((nf+1)/2) * (W/nf + 0.18u)'
+ ps='2*int((nf+2)/2) * (W/nf + 0.18u)' nrd='0.18u / W' nrs='0.18u / W' sa=0 sb=0 sd=0 m=1
XMTP PSRC VBP VDD VDD pfet_03v3 L=1u W=48u nf=1 ad='int((nf+1)/2) * W/nf * 0.18u' as='int((nf+2)/2) * W/nf * 0.18u' pd='2*int((nf+1)/2) * (W/nf + 0.18u)'
+ ps='2*int((nf+2)/2) * (W/nf + 0.18u)' nrd='0.18u / W' nrs='0.18u / W' sa=0 sb=0 sd=0 m=1
XMP1 PDA VREF PSRC PSRC pfet_03v3 L=1u W=48u nf=1 ad='int((nf+1)/2) * W/nf * 0.18u' as='int((nf+2)/2) * W/nf * 0.18u' pd='2*int((nf+1)/2) * (W/nf + 0.18u)'
+ ps='2*int((nf+2)/2) * (W/nf + 0.18u)' nrd='0.18u / W' nrs='0.18u / W' sa=0 sb=0 sd=0 m=1
XMP2 VDUMP VDUMP PSRC PSRC pfet_03v3 L=1u W=48u nf=1 ad='int((nf+1)/2) * W/nf * 0.18u' as='int((nf+2)/2) * W/nf * 0.18u' pd='2*int((nf+1)/2) * (W/nf + 0.18u)'
+ ps='2*int((nf+2)/2) * (W/nf + 0.18u)' nrd='0.18u / W' nrs='0.18u / W' sa=0 sb=0 sd=0 m=1
XMP3 PDA PDA VSS VSS nfet_03v3 L=1u W=16u nf=1 ad='int((nf+1)/2) * W/nf * 0.18u' as='int((nf+2)/2) * W/nf * 0.18u' pd='2*int((nf+1)/2) * (W/nf + 0.18u)'
+ ps='2*int((nf+2)/2) * (W/nf + 0.18u)' nrd='0.18u / W' nrs='0.18u / W' sa=0 sb=0 sd=0 m=1
XMP4 VDUMP PDA VSS VSS nfet_03v3 L=1u W=16u nf=1 ad='int((nf+1)/2) * W/nf * 0.18u' as='int((nf+2)/2) * W/nf * 0.18u' pd='2*int((nf+1)/2) * (W/nf + 0.18u)'
+ ps='2*int((nf+2)/2) * (W/nf + 0.18u)' nrd='0.18u / W' nrs='0.18u / W' sa=0 sb=0 sd=0 m=1
.ends

* expanding   symbol:  tgate_3v3.sym # of pins=6
** sym_path: design/tgate_3v3.sym
** sch_path: design/tgate_3v3.sch
.subckt tgate_3v3 A Y GN GP VDD VSS
*.iopin A
*.iopin Y
*.ipin GN
*.ipin GP
*.iopin VDD
*.iopin VSS
XMP Y GP A VDD pfet_03v3 L=0.28u W=2.5u nf=1 ad='int((nf+1)/2) * W/nf * 0.18u' as='int((nf+2)/2) * W/nf * 0.18u' pd='2*int((nf+1)/2) * (W/nf + 0.18u)'
+ ps='2*int((nf+2)/2) * (W/nf + 0.18u)' nrd='0.18u / W' nrs='0.18u / W' sa=0 sb=0 sd=0 m=1
XMN A GN Y VSS nfet_03v3 L=0.28u W=1u nf=1 ad='int((nf+1)/2) * W/nf * 0.18u' as='int((nf+2)/2) * W/nf * 0.18u' pd='2*int((nf+1)/2) * (W/nf + 0.18u)'
+ ps='2*int((nf+2)/2) * (W/nf + 0.18u)' nrd='0.18u / W' nrs='0.18u / W' sa=0 sb=0 sd=0 m=1
.ends

* gf180-pll :: output-range :: closed-loop output-band coverage testbench (#12)
*
* DUT: `pll_top` -- the SAME whole-PLL DUT as sim/lock-time, sim/pll-top-smoke
* and sim/supply-sensitivity: design/pll_top.sch, netlisted by
* design/netlist.sh into design/netlist/pll_top.spice and prepended to this
* fragment by sim/lib/pll_top_dut.sh (#52).  This bench answers a different
* question than lock-time: not "how long does the loop take to lock", but
* "does the loop reach the ratified output-band EDGE frequencies at all, and
* with how much control-voltage headroom to the usable 0.9-2.7 V window" --
* complementing (not re-deriving) #8's open-loop vco-tuning-range
* characterization, which is what this bench's initial condition and target
* selection are taken from (see run.sh).
*
* MIGRATED FROM sim/lib/assemble_closed_loop.sh (#159), in lockstep with
* sim/lock-time and for the same reason: the loop's top-level wiring now
* comes from design/pll_top.sch instead of from this testbench's own instance
* list, so no two campaigns can disagree about the connectivity without the
* schematic diff showing it.  Every record already in
* sim/output-range/records/ was taken against the older assembly and names it
* in its own Netlist provenance field; those records are append-only evidence
* and are not restated or reinterpreted here.  See
* sim/lock-time/testbench/tb_lock_time.sp's header for the itemised list of
* what changed -- this deck took exactly the same changes.
*
* Same net names, stimulus and topology as tb_lock_time.sp; see that file's
* header for the full description.
*
* Expects from the generated header (sim/lib/simenv.sh): the same param set
* as tb_lock_time.sp (vsup, fref, b*_code, cpb*_code, sel*_code, p*_code,
* iunit, vctrl_ic, t_force, tstep, tstop, tmax, lockthresh). vctrl_ic here is
* NOT cold-start-vs-re-lock -- it is run.sh's best open-loop estimate of the
* locked Vctrl (from sim/vco-tuning-range's own measured f(Vctrl) table),
* used ONLY to keep the required simulated transient short enough to be
* tractable (see this record's Methodology field): the loop still closes and
* settles on its own, this just avoids re-proving cold-start slewing, which
* is lock-time's (#12) job, not this bench's.

*------------------------------------------------------------------ supplies
vvdd    vdd     0 dc 'vsup'
vvddvco vdd_vco 0 dc 'vsup'
vvdddiv vdd_div 0 dc 'vsup'
vgndvco gnd_vco 0 dc 0
vvss    vss     0 dc 0

*----------------------------------------------------------- reference clock
vref ref 0 pulse(0 'vsup' 20n 200p 200p '0.5/fref-200p' '1/fref')

*----------------------------------------------------- static configuration
* Encoded by sim/lib/pll_top_dut.sh (cloop_band_params / cloop_trim_params /
* cloop_divider_params), not by this deck -- see tb_lock_time.sp's header.
vb0   b0   0 dc 'vsup*b0_code'
vb1   b1   0 dc 'vsup*b1_code'
vb2   b2   0 dc 'vsup*b2_code'
vcpb0 cpb0 0 dc 'vsup*cpb0_code'
vcpb1 cpb1 0 dc 'vsup*cpb1_code'
vp0   p0   0 dc 'vsup*p0_code'
vp1   p1   0 dc 'vsup*p1_code'
vp2   p2   0 dc 'vsup*p2_code'
vp3   p3   0 dc 'vsup*p3_code'
vp4   p4   0 dc 'vsup*p4_code'
vp5   p5   0 dc 'vsup*p5_code'
vs0   sel0 0 dc 'vsup*sel0_code'
vs1   sel1 0 dc 'vsup*sel1_code'
vs2   sel2 0 dc 'vsup*sel2_code'
vs3   sel3 0 dc 'vsup*sel3_code'
vs4   sel4 0 dc 'vsup*sel4_code'
vs5   sel5 0 dc 'vsup*sel5_code'

iibn vdd ibn dc 'iunit'
iicn vdd icn dc 'iunit'
iibp ibp 0 dc 'iunit'
iicp icp 0 dc 'iunit'

*--------------------------------------------------------------------- DUT
* Generated by sim/lib/pll_top_dut.sh's `cloop_instance`.
xdut ref b0 b1 b2 cpb0 cpb1 p0 p1 p2 p3 p4 p5 sel0 sel1 sel2 sel3 sel4 sel5
+ ibn icn ibp icp clk divout fb lock vctrl vdd vdd_vco gnd_vco vdd_div vss
+ pll_top

.ic v(xdut.xvco.y1)=0 v(xdut.xvco.y2)='vsup' v(xdut.xvco.y3)=0
+ v(xdut.xvco.y4)='vsup' v(xdut.xvco.y5)=0

* Released clamp seeding VCTRL near run.sh's open-loop estimate of the
* locked value (see header comment above and this record's Methodology) --
* same mechanism as tb_lock_time.sp.
vsetv vsetnode 0 dc 'vctrl_ic'
* Release transition sized as a multiple of the internal-timestep ceiling
* (#65) -- same fix as tb_lock_time.sp's identical mechanism, applied here
* preemptively for the same root cause: at the OLD 100 ps tr/tf (equal to
* the 100 ps ceiling), the switch's Ron(10)/Roff(1G) discontinuity spans
* exactly one ceiling-sized step, which sim/lock-time's cold-start row
* (vctrl_ic=0.9V, at a rail) showed ngspice cannot resolve -- "Timestep too
* small", 100% reproducible, independent of corner or host load. This bench
* was NOT observed to reproduce the crash at its one checked point
* (typical/27C/3.30V, `lo` edge, vctrl_ic ~1.68V mid-window rather than at a
* rail) before this fix landed, but shares the identical model/mechanism, so
* the fix is applied defensively rather than waiting for a corner where the
* discontinuity happens to be sharp enough to fail. See this campaign's
* sibling investigation record (sim/lock-time) for the full root-cause.
vsctrl sctrl 0 pulse('vsup' 0 't_force' '10*tmax' '10*tmax' '2*tstop' '4*tstop')
sforce vctrl vsetnode sctrl 0 SWFORCE
.model SWFORCE SW(Ron=10 Roff=1G Vt='vsup/2' Vh=0)

* rshunt / itl4 are REQUIRED on this DUT and are solver knobs only -- every
* convergence TOLERANCE is this campaign's own, unchanged from before #159,
* so the converged solution is the one this campaign has always reported.
* See tb_lock_time.sp's identical `.options` note for the bisection that
* established rshunt is not optional here (without it the migrated deck
* aborts inside the SWFORCE release ramp on the loop filter's nonlinear
* moscap branch) and for the floating-cascode-node reason sim/pfd-deadzone,
* sim/pll-top-smoke and sim/supply-sensitivity all carry the same 1 Tohm
* shunt.
.options rshunt=1e12 itl4=200 reltol=1e-3 abstol=1e-9 vntol=1e-4 chgtol=1e-13

* The transient is issued ONCE, from the `.control` block at the bottom,
* rather than from a top-level `.tran` card that ngspice batch mode would
* then re-run a second time -- see tb_lock_time.sp's identical note, and
* sim/pll-top-smoke/testbench/tb_pll_smoke.sp, which documented the
* mechanism this campaign's own records had reported as ngspice
* "re-entering its own analysis path" after printing complete measurements.
*
* The 4th transient argument (tmax) is LOAD-BEARING -- see tb_lock_time.sp's
* identical note and sim/lib/simenv.sh's SIMENV_CLOSED_LOOP_TMAX. This bench
* was the worse of the two violators before #65: with the ceiling defaulting
* to the print step {tstep} = 1/(50*f_out), the 10 MHz `lo` edge ran at a 2 ns
* internal ceiling, and 91% of its measured internal steps were LONGER than
* the PFD's entire 0.33-0.39 ns set pulse.
.csparam c_tstep={tstep}
.csparam c_tstop={tstop}
.csparam c_tmax={tmax}

*------------------------------------------------------------- measurements
* Same real lock_detector criterion as tb_lock_time.sp -- this bench also
* reports whether the loop actually LOCKED at the target frequency, not just
* that Vctrl landed somewhere plausible.
.measure tran t_lock_last_rise when v(lock)='lockthresh' rise=last
.measure tran lock_at_end find v(lock) at='tstop-1p'
* The control-voltage margin measurement this campaign exists for.
.measure tran vctrl_final find v(vctrl) at='tstop-1p'

* PFD DN-branch integration guard (#69) -- see tb_lock_time.sp's identical
* measure for the full rationale.  This campaign is where the guard was
* validated: at the pre-#75 ceiling the `lo` edge derived a 2.0 ns internal
* timestep from its 10 MHz output (~6x the PFD's 0.33-0.39 ns set pulse) and
* this measure read 6.6e-7 V against a 9.9e-4 V floor -- the DN branch was not
* asserting at all, while the campaign's own verdict table showed nothing
* unusual.  run.sh scores it three-valued (PASS / FAIL / SUSPECT / ERROR).
* DN is internal to pll_top since #159, hence the hierarchical reference.
.measure tran dn_lvl avg v(xdut.dn) from='0.9*tstop' to='tstop-1p'

* Full-transient waveform capture -- see tb_lock_time.sp's header comment
* above the identical `.control` block for the rationale (#49's Vctrl-anomaly
* prerequisite; no extra analysis cost, left on unconditionally).
.control
  set noaskquit
  * Only the vectors the `.meas` cards and the waveform artifact read -- see
  * tb_lock_time.sp's identical list for why an unrestricted save is not
  * viable on a ~390-node DUT at this timestep ceiling.
  save v(vctrl) v(lock) v(xdut.up) v(xdut.dn) v(xdut.vwin)
  tran $&c_tstep $&c_tstop 0 $&c_tmax
  wrdata waveform.csv v(vctrl) v(xdut.up) v(xdut.dn) v(lock) v(xdut.vwin)
.endc

* ==== deck 2 of 2: sim/output-range/work/dut_output_range_trace.sp ====
* The stall-trace deck, generated by sim/output-range/testbench/stall_trace.sh.
* Identical to deck 1 except for its .control block and one .csparam;
* audit with `./stall_trace.sh --show-diff`.
* ASSEMBLED by sim/lib/pll_top_dut.sh -- do not edit.
* DUT: design/netlist/pll_top.spice (export of design/pll_top.sch, #52)
* Stimulus: sim/output-range/testbench/tb_output_range.sp
* gf180-pll :: pll_top -- generated by design/netlist.sh from pll_top.sch
* xschem XSCHEM V3.4.7; do not edit by hand.
** sch_path: design/pll_top.sch
.subckt pll_top REF B0 B1 B2 CPB0 CPB1 P0 P1 P2 P3 P4 P5 SEL0 SEL1 SEL2 SEL3 SEL4 SEL5 IBN ICN IBP ICP CLK DIVOUT FB LOCK VCTRL
+ VDD VDD_VCO GND_VCO VDD_DIV VSS
*.ipin REF
*.ipin B0
*.ipin B1
*.ipin B2
*.ipin CPB0
*.ipin CPB1
*.ipin P0
*.ipin P1
*.ipin P2
*.ipin P3
*.ipin P4
*.ipin P5
*.ipin SEL0
*.ipin SEL1
*.ipin SEL2
*.ipin SEL3
*.ipin SEL4
*.ipin SEL5
*.ipin IBN
*.ipin ICN
*.ipin IBP
*.ipin ICP
*.opin CLK
*.opin DIVOUT
*.opin FB
*.opin LOCK
*.iopin VCTRL
*.iopin VDD
*.iopin VDD_VCO
*.iopin GND_VCO
*.iopin VDD_DIV
*.iopin VSS
XPFD REF FB CPB0 CPB1 IBN ICN IBP ICP VCTRL UP DN VDD VSS pfd_cp
XLF VCTRL VSS loop_filter
XVCO VCTRL B0 B1 B2 CLK VDD_VCO GND_VCO vco
XDIV CLK P0 P1 P2 P3 P4 P5 SEL0 SEL1 SEL2 SEL3 SEL4 SEL5 DIVOUT FB VDD_DIV VSS divider_chain
XLD UP DN LOCK VWIN VDD VSS lock_detector
.ends

* expanding   symbol:  pfd_cp.sym # of pins=13
** sym_path: design/pfd_cp.sym
** sch_path: design/pfd_cp.sch
.subckt pfd_cp REF FB B0 B1 IBN ICN IBP ICP VOUT UP DN VDD VSS
*.ipin REF
*.ipin FB
*.ipin B0
*.ipin B1
*.iopin IBN
*.iopin ICN
*.iopin IBP
*.iopin ICP
*.iopin VOUT
*.opin UP
*.opin DN
*.iopin VDD
*.iopin VSS
xpfd REF FB UP DN VDD VSS pfd
xcp UP DN B0 B1 IBN ICN IBP ICP VOUT VDD VSS cp
.ends

* expanding   symbol:  loop_filter.sym # of pins=2
** sym_path: design/loop_filter.sym
** sch_path: design/loop_filter.sch
.subckt loop_filter VCTRL VSS
*.iopin VCTRL
*.iopin VSS
XRF1 NR1 VCTRL VSS ppolyf_u r_width=2u r_length=107u m=1
XRF2 NR2 NR1 VSS ppolyf_u r_width=2u r_length=107u m=1
XRF3 NR3 NR2 VSS ppolyf_u r_width=2u r_length=107u m=1
XRF4 NZ NR3 VSS ppolyf_u r_width=2u r_length=107u m=1
XCF1 NZ VSS cap_nmos_03v3_b c_width=87u c_length=87u m=1
XCF2 NZ VSS cap_nmos_03v3_b c_width=87u c_length=87u m=1
XCF3 NZ VSS cap_nmos_03v3_b c_width=87u c_length=87u m=1
XCF4 NZ VSS cap_nmos_03v3_b c_width=87u c_length=87u m=1
XCF5 VCTRL VSS cap_mim_2f0_m2m3_noshield c_width=31.4u c_length=31.4u m=1
.ends

* expanding   symbol:  vco.sym # of pins=7
** sym_path: design/vco.sym
** sch_path: design/vco.sch
.subckt vco VCTRL B0 B1 B2 CLK VDD_VCO GND_VCO
*.ipin VCTRL
*.ipin B0
*.ipin B1
*.ipin B2
*.opin CLK
*.iopin VDD_VCO
*.iopin GND_VCO
XBIAS VCTRL B0 B1 B2 VBP VBN VDD_VCO GND_VCO vco_bias
XS1 Y5 Y1 VDD_VCO GND_VCO VBP VBN vco_stage
XS2 Y1 Y2 VDD_VCO GND_VCO VBP VBN vco_stage
XS3 Y2 Y3 VDD_VCO GND_VCO VBP VBN vco_stage
XS4 Y3 Y4 VDD_VCO GND_VCO VBP VBN vco_stage
XS5 Y4 Y5 VDD_VCO GND_VCO VBP VBN vco_stage
XMBP1 NB1 Y5 VDD_VCO VDD_VCO pfet_03v3 L=0.28u W=1.25u nf=1 ad='int((nf+1)/2) * W/nf * 0.18u' as='int((nf+2)/2) * W/nf * 0.18u' pd='2*int((nf+1)/2) * (W/nf + 0.18u)'
+ ps='2*int((nf+2)/2) * (W/nf + 0.18u)' nrd='0.18u / W' nrs='0.18u / W' sa=0 sb=0 sd=0 m=1
XMBN1 NB1 Y5 GND_VCO GND_VCO nfet_03v3 L=0.28u W=0.5u nf=1 ad='int((nf+1)/2) * W/nf * 0.18u' as='int((nf+2)/2) * W/nf * 0.18u' pd='2*int((nf+1)/2) * (W/nf + 0.18u)'
+ ps='2*int((nf+2)/2) * (W/nf + 0.18u)' nrd='0.18u / W' nrs='0.18u / W' sa=0 sb=0 sd=0 m=1
XMBP2 NB2 NB1 VDD_VCO VDD_VCO pfet_03v3 L=0.28u W=3.75u nf=1 ad='int((nf+1)/2) * W/nf * 0.18u' as='int((nf+2)/2) * W/nf * 0.18u' pd='2*int((nf+1)/2) * (W/nf + 0.18u)'
+ ps='2*int((nf+2)/2) * (W/nf + 0.18u)' nrd='0.18u / W' nrs='0.18u / W' sa=0 sb=0 sd=0 m=1
XMBN2 NB2 NB1 GND_VCO GND_VCO nfet_03v3 L=0.28u W=1.5u nf=1 ad='int((nf+1)/2) * W/nf * 0.18u' as='int((nf+2)/2) * W/nf * 0.18u' pd='2*int((nf+1)/2) * (W/nf + 0.18u)'
+ ps='2*int((nf+2)/2) * (W/nf + 0.18u)' nrd='0.18u / W' nrs='0.18u / W' sa=0 sb=0 sd=0 m=1
XMBP3 CLK NB2 VDD_VCO VDD_VCO pfet_03v3 L=0.28u W=11.25u nf=1 ad='int((nf+1)/2) * W/nf * 0.18u' as='int((nf+2)/2) * W/nf * 0.18u' pd='2*int((nf+1)/2) * (W/nf + 0.18u)'
+ ps='2*int((nf+2)/2) * (W/nf + 0.18u)' nrd='0.18u / W' nrs='0.18u / W' sa=0 sb=0 sd=0 m=1
XMBN3 CLK NB2 GND_VCO GND_VCO nfet_03v3 L=0.28u W=4.5u nf=1 ad='int((nf+1)/2) * W/nf * 0.18u' as='int((nf+2)/2) * W/nf * 0.18u' pd='2*int((nf+1)/2) * (W/nf + 0.18u)'
+ ps='2*int((nf+2)/2) * (W/nf + 0.18u)' nrd='0.18u / W' nrs='0.18u / W' sa=0 sb=0 sd=0 m=1
XCDEC1 VDD_VCO GND_VCO cap_nmos_03v3 c_width=50u c_length=50u m=1
XCDEC2 VDD_VCO GND_VCO cap_nmos_03v3 c_width=50u c_length=50u m=1
.ends

* expanding   symbol:  divider_chain.sym # of pins=17
** sym_path: design/divider_chain.sym
** sch_path: design/divider_chain.sch
.subckt divider_chain VCO P0 P1 P2 P3 P4 P5 SEL0 SEL1 SEL2 SEL3 SEL4 SEL5 DIVOUT FB VDD_DIV VSS
*.ipin VCO
*.ipin P0
*.ipin P1
*.ipin P2
*.ipin P3
*.ipin P4
*.ipin P5
*.ipin SEL0
*.ipin SEL1
*.ipin SEL2
*.ipin SEL3
*.ipin SEL4
*.ipin SEL5
*.opin DIVOUT
*.opin FB
*.iopin VDD_DIV
*.iopin VSS
XD0 VCO MI0 P0 CK1 MO0 VDD_DIV VSS div23_cell
XD1 CK1 MI1 P1 CK2 MO1 VDD_DIV VSS div23_cell
XD2 CK2 MI2 P2 CK3 MO2 VDD_DIV VSS div23_cell
XD3 CK3 MI3 P3 CK4 MO3 VDD_DIV VSS div23_cell
XD4 CK4 MI4 P4 CK5 MO4 VDD_DIV VSS div23_cell
XD5 CK5 SEL5 P5 CK6 MO5 VDD_DIV VSS div23_cell
XNR0 MO1 SEL0 NMI0 VDD_DIV VSS nor2_3v3
XIV0 NMI0 MI0 VDD_DIV VSS inv_3v3
XNR1 MO2 SEL1 NMI1 VDD_DIV VSS nor2_3v3
XIV1 NMI1 MI1 VDD_DIV VSS inv_3v3
XNR2 MO3 SEL2 NMI2 VDD_DIV VSS nor2_3v3
XIV2 NMI2 MI2 VDD_DIV VSS inv_3v3
XNR3 MO4 SEL3 NMI3 VDD_DIV VSS nor2_3v3
XIV3 NMI3 MI3 VDD_DIV VSS inv_3v3
XNR4 MO5 SEL4 NMI4 VDD_DIV VSS nor2_3v3
XIV4 NMI4 MI4 VDD_DIV VSS inv_3v3
XM0 CK1 SEL0 T0 VDD_DIV VSS nand2_3v3
XM1 CK2 SEL1 T1 VDD_DIV VSS nand2_3v3
XM2 CK3 SEL2 T2 VDD_DIV VSS nand2_3v3
XM3 CK4 SEL3 T3 VDD_DIV VSS nand2_3v3
XM4 CK5 SEL4 T4 VDD_DIV VSS nand2_3v3
XM5 CK6 SEL5 T5 VDD_DIV VSS nand2_3v3
XMA T0 T1 T2 MA VDD_DIV VSS nand3_3v3
XMB T3 T4 T5 MB VDD_DIV VSS nand3_3v3
XMNO MA MB DIVOUTB VDD_DIV VSS nor2_3v3
XIDO DIVOUTB DIVOUT VDD_DIV VSS inv2x_3v3
XFRT DIVOUT VCO FB FBB VDD_DIV VSS dff_tg_3v3
.ends

* expanding   symbol:  lock_detector.sym # of pins=6
** sym_path: design/lock_detector.sym
** sch_path: design/lock_detector.sch
.subckt lock_detector UP DN LOCK VWIN VDD VSS
*.ipin UP
*.ipin DN
*.opin LOCK
*.opin VWIN
*.iopin VDD
*.iopin VSS
XERR UP DN ERR VDD VSS xor2_3v3
XDLY ERR ERRD VDD VSS delaywin_3v3
XNW ERR ERRD WIDEB VDD VSS nand2_3v3
XIW WIDEB WIDE VDD VSS inv_3v3
XMDNW VWIN WIDE VSS VSS nfet_03v3 L=0.5u W=2u nf=1 ad='int((nf+1)/2) * W/nf * 0.18u' as='int((nf+2)/2) * W/nf * 0.18u' pd='2*int((nf+1)/2) * (W/nf + 0.18u)'
+ ps='2*int((nf+2)/2) * (W/nf + 0.18u)' nrd='0.18u / W' nrs='0.18u / W' sa=0 sb=0 sd=0 m=1
XMUPW VWIN VSS VDD VDD pfet_03v3 L=20u W=0.22u nf=1 ad='int((nf+1)/2) * W/nf * 0.18u' as='int((nf+2)/2) * W/nf * 0.18u' pd='2*int((nf+1)/2) * (W/nf + 0.18u)'
+ ps='2*int((nf+2)/2) * (W/nf + 0.18u)' nrd='0.18u / W' nrs='0.18u / W' sa=0 sb=0 sd=0 m=1
XMCW VSS VWIN VSS VSS nfet_03v3 L=6u W=30u nf=1 ad='int((nf+1)/2) * W/nf * 0.18u' as='int((nf+2)/2) * W/nf * 0.18u' pd='2*int((nf+1)/2) * (W/nf + 0.18u)'
+ ps='2*int((nf+2)/2) * (W/nf + 0.18u)' nrd='0.18u / W' nrs='0.18u / W' sa=0 sb=0 sd=0 m=1
XSCH VWIN LOCKB VDD VSS schmitt_3v3
XILK LOCKB LOCK VDD VSS inv_3v3
.ends

* expanding   symbol:  pfd.sym # of pins=6
** sym_path: design/pfd.sym
** sch_path: design/pfd.sch
.subckt pfd REF FB UP DN VDD VSS
*.ipin REF
*.ipin FB
*.opin UP
*.opin DN
*.iopin VDD
*.iopin VSS
xed_ref REF PR VDD VSS edgedet
xed_fb FB PF VDD VSS edgedet
xinv_sr PR SBR VDD VSS pfdcp_inv_3v3
xinv_sf PF SBF VDD VSS pfdcp_inv_3v3
xlat_ref SBR RB UP UPB VDD VSS srlatch
xlat_fb SBF RB DN DNB VDD VSS srlatch
xnand_rst UP DN NRST VDD VSS pfdcp_nand2_3v3
xinv_r0 NRST RST_RAW VDD VSS pfdcp_inv_3v3
xd1 RST_RAW RD1 VDD VSS pfdcp_inv_3v3
xd2 RD1 RD2 VDD VSS pfdcp_inv_3v3
xd3 RD2 RD3 VDD VSS pfdcp_inv_3v3
xd4 RD3 RD4 VDD VSS pfdcp_inv_3v3
xd5 RD4 RD5 VDD VSS pfdcp_inv_3v3
xd6 RD5 RD6 VDD VSS pfdcp_inv_3v3
xd7 RD6 RD7 VDD VSS pfdcp_inv_3v3
xd8 RD7 RD8 VDD VSS pfdcp_inv_3v3
xd9 RD8 RD9 VDD VSS pfdcp_inv_3v3
xd10 RD9 RD10 VDD VSS pfdcp_inv_3v3
xd11 RD10 RD11 VDD VSS pfdcp_inv_3v3
xd12 RD11 RD12 VDD VSS pfdcp_inv_3v3
xd13 RD12 RD13 VDD VSS pfdcp_inv_3v3
xd14 RD13 RD14 VDD VSS pfdcp_inv_3v3
xd15 RD14 RD15 VDD VSS pfdcp_inv_3v3
xd16 RD15 RD16 VDD VSS pfdcp_inv_3v3
xd17 RD16 RD17 VDD VSS pfdcp_inv_3v3
xd18 RD17 RD18 VDD VSS pfdcp_inv_3v3
xd19 RD18 RD19 VDD VSS pfdcp_inv_3v3
xd20 RD19 RD20 VDD VSS pfdcp_inv_3v3
xd21 RD20 RD21 VDD VSS pfdcp_inv_3v3
xd22 RD21 RD22 VDD VSS pfdcp_inv_3v3
xd23 RD22 RD23 VDD VSS pfdcp_inv_3v3
xd24 RD23 RST_DLY VDD VSS pfdcp_inv_3v3
xinv_rb RST_DLY RB VDD VSS pfdcp_inv_3v3
.ends

* expanding   symbol:  cp.sym # of pins=11
** sym_path: design/cp.sym
** sch_path: design/cp.sch
.subckt cp UP DN B0 B1 IBN ICN IBP ICP VOUT VDD VSS
*.ipin UP
*.ipin DN
*.ipin B0
*.ipin B1
*.iopin IBN
*.iopin ICN
*.iopin IBP
*.iopin ICP
*.iopin VOUT
*.iopin VDD
*.iopin VSS
XMBN IBN IBN VSS VSS nfet_03v3 L=1u W=16u nf=1 ad='int((nf+1)/2) * W/nf * 0.18u' as='int((nf+2)/2) * W/nf * 0.18u' pd='2*int((nf+1)/2) * (W/nf + 0.18u)'
+ ps='2*int((nf+2)/2) * (W/nf + 0.18u)' nrd='0.18u / W' nrs='0.18u / W' sa=0 sb=0 sd=0 m=1
XMCN ICN ICN VSS VSS nfet_03v3 L=1u W=4u nf=1 ad='int((nf+1)/2) * W/nf * 0.18u' as='int((nf+2)/2) * W/nf * 0.18u' pd='2*int((nf+1)/2) * (W/nf + 0.18u)'
+ ps='2*int((nf+2)/2) * (W/nf + 0.18u)' nrd='0.18u / W' nrs='0.18u / W' sa=0 sb=0 sd=0 m=1
XMBP IBP IBP VDD VDD pfet_03v3 L=1u W=48u nf=1 ad='int((nf+1)/2) * W/nf * 0.18u' as='int((nf+2)/2) * W/nf * 0.18u' pd='2*int((nf+1)/2) * (W/nf + 0.18u)'
+ ps='2*int((nf+2)/2) * (W/nf + 0.18u)' nrd='0.18u / W' nrs='0.18u / W' sa=0 sb=0 sd=0 m=1
XMCP ICP ICP VDD VDD pfet_03v3 L=1u W=12u nf=1 ad='int((nf+1)/2) * W/nf * 0.18u' as='int((nf+2)/2) * W/nf * 0.18u' pd='2*int((nf+1)/2) * (W/nf + 0.18u)'
+ ps='2*int((nf+2)/2) * (W/nf + 0.18u)' nrd='0.18u / W' nrs='0.18u / W' sa=0 sb=0 sd=0 m=1
xi_b0 B0 B0B VDD VSS pfdcp_inv_3v3
xi_b1 B1 B1B VDD VSS pfdcp_inv_3v3
xi_up UP UPB VDD VSS pfdcp_inv_3v3
xi_dn DN DNB VDD VSS pfdcp_inv_3v3
xn_base IBN ICN VDD VSS DNT VSS cp_leg_n
xn_t0 IBN ICN B0 B0B DNT VSS cp_leg_n
xn_t1a IBN ICN B1 B1B DNT VSS cp_leg_n
xn_t1b IBN ICN B1 B1B DNT VSS cp_leg_n
xp_base IBP ICP VDD VSS UPT VDD cp_leg_p
xp_t0 IBP ICP B0 B0B UPT VDD cp_leg_p
xp_t1a IBP ICP B1 B1B UPT VDD cp_leg_p
xp_t1b IBP ICP B1 B1B UPT VDD cp_leg_p
XMSWDN VOUT DN DNT VSS nfet_03v3 L=0.3u W=6u nf=1 ad='int((nf+1)/2) * W/nf * 0.18u' as='int((nf+2)/2) * W/nf * 0.18u' pd='2*int((nf+1)/2) * (W/nf + 0.18u)'
+ ps='2*int((nf+2)/2) * (W/nf + 0.18u)' nrd='0.18u / W' nrs='0.18u / W' sa=0 sb=0 sd=0 m=1
XMDMPDN VDUMP DNB DNT VSS nfet_03v3 L=0.3u W=6u nf=1 ad='int((nf+1)/2) * W/nf * 0.18u' as='int((nf+2)/2) * W/nf * 0.18u' pd='2*int((nf+1)/2) * (W/nf + 0.18u)'
+ ps='2*int((nf+2)/2) * (W/nf + 0.18u)' nrd='0.18u / W' nrs='0.18u / W' sa=0 sb=0 sd=0 m=1
XMSWUP VOUT UPB UPT VDD pfet_03v3 L=0.3u W=6u nf=1 ad='int((nf+1)/2) * W/nf * 0.18u' as='int((nf+2)/2) * W/nf * 0.18u' pd='2*int((nf+1)/2) * (W/nf + 0.18u)'
+ ps='2*int((nf+2)/2) * (W/nf + 0.18u)' nrd='0.18u / W' nrs='0.18u / W' sa=0 sb=0 sd=0 m=1
XMDMPUP VDUMP UP UPT VDD pfet_03v3 L=0.3u W=6u nf=1 ad='int((nf+1)/2) * W/nf * 0.18u' as='int((nf+2)/2) * W/nf * 0.18u' pd='2*int((nf+1)/2) * (W/nf + 0.18u)'
+ ps='2*int((nf+2)/2) * (W/nf + 0.18u)' nrd='0.18u / W' nrs='0.18u / W' sa=0 sb=0 sd=0 m=1
XMDUMN VOUT DNB VOUT VSS nfet_03v3 L=0.3u W=3u nf=1 ad='int((nf+1)/2) * W/nf * 0.18u' as='int((nf+2)/2) * W/nf * 0.18u' pd='2*int((nf+1)/2) * (W/nf + 0.18u)'
+ ps='2*int((nf+2)/2) * (W/nf + 0.18u)' nrd='0.18u / W' nrs='0.18u / W' sa=0 sb=0 sd=0 m=1
XMDUMP VOUT UP VOUT VDD pfet_03v3 L=0.3u W=3u nf=1 ad='int((nf+1)/2) * W/nf * 0.18u' as='int((nf+2)/2) * W/nf * 0.18u' pd='2*int((nf+1)/2) * (W/nf + 0.18u)'
+ ps='2*int((nf+2)/2) * (W/nf + 0.18u)' nrd='0.18u / W' nrs='0.18u / W' sa=0 sb=0 sd=0 m=1
xbuf VOUT IBN IBP VDUMP VDD VSS cp_dumpbuf
.ends

* expanding   symbol:  vco_bias.sym # of pins=8
** sym_path: design/vco_bias.sym
** sch_path: design/vco_bias.sch
.subckt vco_bias VCTRL B0 B1 B2 VBP VBN VDD VSS
*.ipin VCTRL
*.ipin B0
*.ipin B1
*.ipin B2
*.iopin VBP
*.iopin VBN
*.iopin VDD
*.iopin VSS
XMP1 NA VBPC VDD VDD pfet_03v3 L=1u W=10u nf=1 ad='int((nf+1)/2) * W/nf * 0.18u' as='int((nf+2)/2) * W/nf * 0.18u' pd='2*int((nf+1)/2) * (W/nf + 0.18u)'
+ ps='2*int((nf+2)/2) * (W/nf + 0.18u)' nrd='0.18u / W' nrs='0.18u / W' sa=0 sb=0 sd=0 m=1
XMP2 VBPC VBPC VDD VDD pfet_03v3 L=1u W=10u nf=1 ad='int((nf+1)/2) * W/nf * 0.18u' as='int((nf+2)/2) * W/nf * 0.18u' pd='2*int((nf+1)/2) * (W/nf + 0.18u)'
+ ps='2*int((nf+2)/2) * (W/nf + 0.18u)' nrd='0.18u / W' nrs='0.18u / W' sa=0 sb=0 sd=0 m=1
XMN1 NA NA VSS VSS nfet_03v3 L=1u W=1.4u nf=1 ad='int((nf+1)/2) * W/nf * 0.18u' as='int((nf+2)/2) * W/nf * 0.18u' pd='2*int((nf+1)/2) * (W/nf + 0.18u)'
+ ps='2*int((nf+2)/2) * (W/nf + 0.18u)' nrd='0.18u / W' nrs='0.18u / W' sa=0 sb=0 sd=0 m=1
XMN2 VBPC NA NC VSS nfet_03v3 L=1u W=5.6u nf=1 ad='int((nf+1)/2) * W/nf * 0.18u' as='int((nf+2)/2) * W/nf * 0.18u' pd='2*int((nf+1)/2) * (W/nf + 0.18u)'
+ ps='2*int((nf+2)/2) * (W/nf + 0.18u)' nrd='0.18u / W' nrs='0.18u / W' sa=0 sb=0 sd=0 m=1
XRCG NC VSS VSS ppolyf_u_3k r_width=1u r_length=5.6u m=1
XMSU1 NSU VSS VDD VDD pfet_03v3 L=20u W=0.22u nf=1 ad='int((nf+1)/2) * W/nf * 0.18u' as='int((nf+2)/2) * W/nf * 0.18u' pd='2*int((nf+1)/2) * (W/nf + 0.18u)'
+ ps='2*int((nf+2)/2) * (W/nf + 0.18u)' nrd='0.18u / W' nrs='0.18u / W' sa=0 sb=0 sd=0 m=1
XMSU2 NSU NA VSS VSS nfet_03v3 L=1u W=2u nf=1 ad='int((nf+1)/2) * W/nf * 0.18u' as='int((nf+2)/2) * W/nf * 0.18u' pd='2*int((nf+1)/2) * (W/nf + 0.18u)'
+ ps='2*int((nf+2)/2) * (W/nf + 0.18u)' nrd='0.18u / W' nrs='0.18u / W' sa=0 sb=0 sd=0 m=1
XMSU3 VBPC NSU VSS VSS nfet_03v3 L=1u W=1u nf=1 ad='int((nf+1)/2) * W/nf * 0.18u' as='int((nf+2)/2) * W/nf * 0.18u' pd='2*int((nf+1)/2) * (W/nf + 0.18u)'
+ ps='2*int((nf+2)/2) * (W/nf + 0.18u)' nrd='0.18u / W' nrs='0.18u / W' sa=0 sb=0 sd=0 m=1
XMPR VFIX VBPC VDD VDD pfet_03v3 L=1u W=2.5u nf=1 ad='int((nf+1)/2) * W/nf * 0.18u' as='int((nf+2)/2) * W/nf * 0.18u' pd='2*int((nf+1)/2) * (W/nf + 0.18u)'
+ ps='2*int((nf+2)/2) * (W/nf + 0.18u)' nrd='0.18u / W' nrs='0.18u / W' sa=0 sb=0 sd=0 m=1
XMD1 VFIX VFIX NMD VSS nfet_03v3 L=1u W=2u nf=1 ad='int((nf+1)/2) * W/nf * 0.18u' as='int((nf+2)/2) * W/nf * 0.18u' pd='2*int((nf+1)/2) * (W/nf + 0.18u)'
+ ps='2*int((nf+2)/2) * (W/nf + 0.18u)' nrd='0.18u / W' nrs='0.18u / W' sa=0 sb=0 sd=0 m=1
XMD2 NMD NMD VSS VSS nfet_03v3 L=1u W=2u nf=1 ad='int((nf+1)/2) * W/nf * 0.18u' as='int((nf+2)/2) * W/nf * 0.18u' pd='2*int((nf+1)/2) * (W/nf + 0.18u)'
+ ps='2*int((nf+2)/2) * (W/nf + 0.18u)' nrd='0.18u / W' nrs='0.18u / W' sa=0 sb=0 sd=0 m=1
XMOFF VBP0 VFIX NOFF VSS nfet_03v3 L=1u W=10u nf=1 ad='int((nf+1)/2) * W/nf * 0.18u' as='int((nf+2)/2) * W/nf * 0.18u' pd='2*int((nf+1)/2) * (W/nf + 0.18u)'
+ ps='2*int((nf+2)/2) * (W/nf + 0.18u)' nrd='0.18u / W' nrs='0.18u / W' sa=0 sb=0 sd=0 m=1
XROFF NOFF VSS VSS ppolyf_u_3k r_width=1u r_length=33u m=1
XMVI VBP0 VCTRL NVI VSS nfet_03v3 L=1u W=10u nf=1 ad='int((nf+1)/2) * W/nf * 0.18u' as='int((nf+2)/2) * W/nf * 0.18u' pd='2*int((nf+1)/2) * (W/nf + 0.18u)'
+ ps='2*int((nf+2)/2) * (W/nf + 0.18u)' nrd='0.18u / W' nrs='0.18u / W' sa=0 sb=0 sd=0 m=1
XRDEG NVI VSS VSS ppolyf_u_3k r_width=1u r_length=33u m=1
XMSUM VBP0 VBP0 VDD VDD pfet_03v3 L=1u W=60u nf=4 ad='int((nf+1)/2) * W/nf * 0.18u' as='int((nf+2)/2) * W/nf * 0.18u' pd='2*int((nf+1)/2) * (W/nf + 0.18u)'
+ ps='2*int((nf+2)/2) * (W/nf + 0.18u)' nrd='0.18u / W' nrs='0.18u / W' sa=0 sb=0 sd=0 m=1
XMIP0 B0B B0 VDD VDD pfet_03v3 L=0.28u W=2u nf=1 ad='int((nf+1)/2) * W/nf * 0.18u' as='int((nf+2)/2) * W/nf * 0.18u' pd='2*int((nf+1)/2) * (W/nf + 0.18u)'
+ ps='2*int((nf+2)/2) * (W/nf + 0.18u)' nrd='0.18u / W' nrs='0.18u / W' sa=0 sb=0 sd=0 m=1
XMIN0 B0B B0 VSS VSS nfet_03v3 L=0.28u W=1u nf=1 ad='int((nf+1)/2) * W/nf * 0.18u' as='int((nf+2)/2) * W/nf * 0.18u' pd='2*int((nf+1)/2) * (W/nf + 0.18u)'
+ ps='2*int((nf+2)/2) * (W/nf + 0.18u)' nrd='0.18u / W' nrs='0.18u / W' sa=0 sb=0 sd=0 m=1
XMIP1 B1B B1 VDD VDD pfet_03v3 L=0.28u W=2u nf=1 ad='int((nf+1)/2) * W/nf * 0.18u' as='int((nf+2)/2) * W/nf * 0.18u' pd='2*int((nf+1)/2) * (W/nf + 0.18u)'
+ ps='2*int((nf+2)/2) * (W/nf + 0.18u)' nrd='0.18u / W' nrs='0.18u / W' sa=0 sb=0 sd=0 m=1
XMIN1 B1B B1 VSS VSS nfet_03v3 L=0.28u W=1u nf=1 ad='int((nf+1)/2) * W/nf * 0.18u' as='int((nf+2)/2) * W/nf * 0.18u' pd='2*int((nf+1)/2) * (W/nf + 0.18u)'
+ ps='2*int((nf+2)/2) * (W/nf + 0.18u)' nrd='0.18u / W' nrs='0.18u / W' sa=0 sb=0 sd=0 m=1
XMIP2 B2B B2 VDD VDD pfet_03v3 L=0.28u W=2u nf=1 ad='int((nf+1)/2) * W/nf * 0.18u' as='int((nf+2)/2) * W/nf * 0.18u' pd='2*int((nf+1)/2) * (W/nf + 0.18u)'
+ ps='2*int((nf+2)/2) * (W/nf + 0.18u)' nrd='0.18u / W' nrs='0.18u / W' sa=0 sb=0 sd=0 m=1
XMIN2 B2B B2 VSS VSS nfet_03v3 L=0.28u W=1u nf=1 ad='int((nf+1)/2) * W/nf * 0.18u' as='int((nf+2)/2) * W/nf * 0.18u' pd='2*int((nf+1)/2) * (W/nf + 0.18u)'
+ ps='2*int((nf+2)/2) * (W/nf + 0.18u)' nrd='0.18u / W' nrs='0.18u / W' sa=0 sb=0 sd=0 m=1
XMA0 VBN1 VBP0 VDD VDD pfet_03v3 L=1u W=26.5u nf=2 ad='int((nf+1)/2) * W/nf * 0.18u' as='int((nf+2)/2) * W/nf * 0.18u' pd='2*int((nf+1)/2) * (W/nf + 0.18u)'
+ ps='2*int((nf+2)/2) * (W/nf + 0.18u)' nrd='0.18u / W' nrs='0.18u / W' sa=0 sb=0 sd=0 m=1
XMA1 VBN1 GA VDD VDD pfet_03v3 L=1u W=17.225u nf=2 ad='int((nf+1)/2) * W/nf * 0.18u' as='int((nf+2)/2) * W/nf * 0.18u' pd='2*int((nf+1)/2) * (W/nf + 0.18u)'
+ ps='2*int((nf+2)/2) * (W/nf + 0.18u)' nrd='0.18u / W' nrs='0.18u / W' sa=0 sb=0 sd=0 m=1
XMSWA0 GA B0B VBP0 VDD pfet_03v3 L=0.5u W=2u nf=1 ad='int((nf+1)/2) * W/nf * 0.18u' as='int((nf+2)/2) * W/nf * 0.18u' pd='2*int((nf+1)/2) * (W/nf + 0.18u)'
+ ps='2*int((nf+2)/2) * (W/nf + 0.18u)' nrd='0.18u / W' nrs='0.18u / W' sa=0 sb=0 sd=0 m=1
XMSWA1 GA B0 VDD VDD pfet_03v3 L=0.5u W=2u nf=1 ad='int((nf+1)/2) * W/nf * 0.18u' as='int((nf+2)/2) * W/nf * 0.18u' pd='2*int((nf+1)/2) * (W/nf + 0.18u)'
+ ps='2*int((nf+2)/2) * (W/nf + 0.18u)' nrd='0.18u / W' nrs='0.18u / W' sa=0 sb=0 sd=0 m=1
XMDA VBN1 VBN1 VSS VSS nfet_03v3 L=1u W=10u nf=1 ad='int((nf+1)/2) * W/nf * 0.18u' as='int((nf+2)/2) * W/nf * 0.18u' pd='2*int((nf+1)/2) * (W/nf + 0.18u)'
+ ps='2*int((nf+2)/2) * (W/nf + 0.18u)' nrd='0.18u / W' nrs='0.18u / W' sa=0 sb=0 sd=0 m=1
XMB0 VBP2 VBN1 VSS VSS nfet_03v3 L=1u W=5u nf=1 ad='int((nf+1)/2) * W/nf * 0.18u' as='int((nf+2)/2) * W/nf * 0.18u' pd='2*int((nf+1)/2) * (W/nf + 0.18u)'
+ ps='2*int((nf+2)/2) * (W/nf + 0.18u)' nrd='0.18u / W' nrs='0.18u / W' sa=0 sb=0 sd=0 m=1
XMB1 VBP2 GB VSS VSS nfet_03v3 L=1u W=8.6125u nf=1 ad='int((nf+1)/2) * W/nf * 0.18u' as='int((nf+2)/2) * W/nf * 0.18u' pd='2*int((nf+1)/2) * (W/nf + 0.18u)'
+ ps='2*int((nf+2)/2) * (W/nf + 0.18u)' nrd='0.18u / W' nrs='0.18u / W' sa=0 sb=0 sd=0 m=1
XMSWB0 GB B1 VBN1 VSS nfet_03v3 L=0.5u W=2u nf=1 ad='int((nf+1)/2) * W/nf * 0.18u' as='int((nf+2)/2) * W/nf * 0.18u' pd='2*int((nf+1)/2) * (W/nf + 0.18u)'
+ ps='2*int((nf+2)/2) * (W/nf + 0.18u)' nrd='0.18u / W' nrs='0.18u / W' sa=0 sb=0 sd=0 m=1
XMSWB1 GB B1B VSS VSS nfet_03v3 L=0.5u W=2u nf=1 ad='int((nf+1)/2) * W/nf * 0.18u' as='int((nf+2)/2) * W/nf * 0.18u' pd='2*int((nf+1)/2) * (W/nf + 0.18u)'
+ ps='2*int((nf+2)/2) * (W/nf + 0.18u)' nrd='0.18u / W' nrs='0.18u / W' sa=0 sb=0 sd=0 m=1
XMDB VBP2 VBP2 VDD VDD pfet_03v3 L=1u W=20u nf=1 ad='int((nf+1)/2) * W/nf * 0.18u' as='int((nf+2)/2) * W/nf * 0.18u' pd='2*int((nf+1)/2) * (W/nf + 0.18u)'
+ ps='2*int((nf+2)/2) * (W/nf + 0.18u)' nrd='0.18u / W' nrs='0.18u / W' sa=0 sb=0 sd=0 m=1
XMC0 VBN VBP2 VDD VDD pfet_03v3 L=1u W=12.3u nf=1 ad='int((nf+1)/2) * W/nf * 0.18u' as='int((nf+2)/2) * W/nf * 0.18u' pd='2*int((nf+1)/2) * (W/nf + 0.18u)'
+ ps='2*int((nf+2)/2) * (W/nf + 0.18u)' nrd='0.18u / W' nrs='0.18u / W' sa=0 sb=0 sd=0 m=1
XMC1 VBN GC VDD VDD pfet_03v3 L=1u W=78.87u nf=8 ad='int((nf+1)/2) * W/nf * 0.18u' as='int((nf+2)/2) * W/nf * 0.18u' pd='2*int((nf+1)/2) * (W/nf + 0.18u)'
+ ps='2*int((nf+2)/2) * (W/nf + 0.18u)' nrd='0.18u / W' nrs='0.18u / W' sa=0 sb=0 sd=0 m=1
XMSWC0 GC B2B VBP2 VDD pfet_03v3 L=0.5u W=2u nf=1 ad='int((nf+1)/2) * W/nf * 0.18u' as='int((nf+2)/2) * W/nf * 0.18u' pd='2*int((nf+1)/2) * (W/nf + 0.18u)'
+ ps='2*int((nf+2)/2) * (W/nf + 0.18u)' nrd='0.18u / W' nrs='0.18u / W' sa=0 sb=0 sd=0 m=1
XMSWC1 GC B2 VDD VDD pfet_03v3 L=0.5u W=2u nf=1 ad='int((nf+1)/2) * W/nf * 0.18u' as='int((nf+2)/2) * W/nf * 0.18u' pd='2*int((nf+1)/2) * (W/nf + 0.18u)'
+ ps='2*int((nf+2)/2) * (W/nf + 0.18u)' nrd='0.18u / W' nrs='0.18u / W' sa=0 sb=0 sd=0 m=1
XMDN VBN VBN VSS VSS nfet_03v3 L=0.5u W=4u nf=1 ad='int((nf+1)/2) * W/nf * 0.18u' as='int((nf+2)/2) * W/nf * 0.18u' pd='2*int((nf+1)/2) * (W/nf + 0.18u)'
+ ps='2*int((nf+2)/2) * (W/nf + 0.18u)' nrd='0.18u / W' nrs='0.18u / W' sa=0 sb=0 sd=0 m=1
XMMN VBP VBN VSS VSS nfet_03v3 L=0.5u W=4u nf=1 ad='int((nf+1)/2) * W/nf * 0.18u' as='int((nf+2)/2) * W/nf * 0.18u' pd='2*int((nf+1)/2) * (W/nf + 0.18u)'
+ ps='2*int((nf+2)/2) * (W/nf + 0.18u)' nrd='0.18u / W' nrs='0.18u / W' sa=0 sb=0 sd=0 m=1
XMDP VBP VBP VDD VDD pfet_03v3 L=0.5u W=10u nf=1 ad='int((nf+1)/2) * W/nf * 0.18u' as='int((nf+2)/2) * W/nf * 0.18u' pd='2*int((nf+1)/2) * (W/nf + 0.18u)'
+ ps='2*int((nf+2)/2) * (W/nf + 0.18u)' nrd='0.18u / W' nrs='0.18u / W' sa=0 sb=0 sd=0 m=1
.ends

* expanding   symbol:  vco_stage.sym # of pins=6
** sym_path: design/vco_stage.sym
** sch_path: design/vco_stage.sch
.subckt vco_stage A Y VDD VSS VBP VBN
*.ipin A
*.opin Y
*.iopin VDD
*.iopin VSS
*.iopin VBP
*.iopin VBN
XMPH NH VBP VDD VDD pfet_03v3 L=0.5u W=10u nf=1 ad='int((nf+1)/2) * W/nf * 0.18u' as='int((nf+2)/2) * W/nf * 0.18u' pd='2*int((nf+1)/2) * (W/nf + 0.18u)'
+ ps='2*int((nf+2)/2) * (W/nf + 0.18u)' nrd='0.18u / W' nrs='0.18u / W' sa=0 sb=0 sd=0 m=1
XMP Y A NH VDD pfet_03v3 L=0.28u W=5u nf=1 ad='int((nf+1)/2) * W/nf * 0.18u' as='int((nf+2)/2) * W/nf * 0.18u' pd='2*int((nf+1)/2) * (W/nf + 0.18u)'
+ ps='2*int((nf+2)/2) * (W/nf + 0.18u)' nrd='0.18u / W' nrs='0.18u / W' sa=0 sb=0 sd=0 m=1
XMN Y A NT VSS nfet_03v3 L=0.28u W=2u nf=1 ad='int((nf+1)/2) * W/nf * 0.18u' as='int((nf+2)/2) * W/nf * 0.18u' pd='2*int((nf+1)/2) * (W/nf + 0.18u)'
+ ps='2*int((nf+2)/2) * (W/nf + 0.18u)' nrd='0.18u / W' nrs='0.18u / W' sa=0 sb=0 sd=0 m=1
XMNT NT VBN VSS VSS nfet_03v3 L=0.5u W=4u nf=1 ad='int((nf+1)/2) * W/nf * 0.18u' as='int((nf+2)/2) * W/nf * 0.18u' pd='2*int((nf+1)/2) * (W/nf + 0.18u)'
+ ps='2*int((nf+2)/2) * (W/nf + 0.18u)' nrd='0.18u / W' nrs='0.18u / W' sa=0 sb=0 sd=0 m=1
.ends

* expanding   symbol:  div23_cell.sym # of pins=7
** sym_path: design/div23_cell.sym
** sch_path: design/div23_cell.sch
.subckt div23_cell CKIN MODIN P CKOUT MODOUT VDD VSS
*.ipin CKIN
*.ipin MODIN
*.ipin P
*.opin CKOUT
*.opin MODOUT
*.iopin VDD
*.iopin VSS
XN3 MODIN P MODOUT SB VDD VSS nand3_3v3
XN2Q QB SB DQN VDD VSS nand2_3v3
XIQ DQN DQ VDD VSS inv_3v3
XFQ DQ CKIN Q QB VDD VSS dff_tg_3v3
XICKO QB CKOUT VDD VSS inv2x_3v3
XN2M MODIN Q NMO VDD VSS nand2_3v3
XIM NMO DMO VDD VSS inv_3v3
XFMO DMO CKIN MODOUT MOB VDD VSS dff_tg_3v3
.ends

* expanding   symbol:  nor2_3v3.sym # of pins=5
** sym_path: design/nor2_3v3.sym
** sch_path: design/nor2_3v3.sch
.subckt nor2_3v3 A B Y VDD VSS
*.ipin A
*.ipin B
*.opin Y
*.iopin VDD
*.iopin VSS
XMPA PMID A VDD VDD pfet_03v3 L=0.28u W=5u nf=1 ad='int((nf+1)/2) * W/nf * 0.18u' as='int((nf+2)/2) * W/nf * 0.18u' pd='2*int((nf+1)/2) * (W/nf + 0.18u)'
+ ps='2*int((nf+2)/2) * (W/nf + 0.18u)' nrd='0.18u / W' nrs='0.18u / W' sa=0 sb=0 sd=0 m=1
XMPB Y B PMID VDD pfet_03v3 L=0.28u W=5u nf=1 ad='int((nf+1)/2) * W/nf * 0.18u' as='int((nf+2)/2) * W/nf * 0.18u' pd='2*int((nf+1)/2) * (W/nf + 0.18u)'
+ ps='2*int((nf+2)/2) * (W/nf + 0.18u)' nrd='0.18u / W' nrs='0.18u / W' sa=0 sb=0 sd=0 m=1
XMNA Y A VSS VSS nfet_03v3 L=0.28u W=1u nf=1 ad='int((nf+1)/2) * W/nf * 0.18u' as='int((nf+2)/2) * W/nf * 0.18u' pd='2*int((nf+1)/2) * (W/nf + 0.18u)'
+ ps='2*int((nf+2)/2) * (W/nf + 0.18u)' nrd='0.18u / W' nrs='0.18u / W' sa=0 sb=0 sd=0 m=1
XMNB Y B VSS VSS nfet_03v3 L=0.28u W=1u nf=1 ad='int((nf+1)/2) * W/nf * 0.18u' as='int((nf+2)/2) * W/nf * 0.18u' pd='2*int((nf+1)/2) * (W/nf + 0.18u)'
+ ps='2*int((nf+2)/2) * (W/nf + 0.18u)' nrd='0.18u / W' nrs='0.18u / W' sa=0 sb=0 sd=0 m=1
.ends

* expanding   symbol:  inv_3v3.sym # of pins=4
** sym_path: design/inv_3v3.sym
** sch_path: design/inv_3v3.sch
.subckt inv_3v3 A Y VDD VSS
*.ipin A
*.opin Y
*.iopin VDD
*.iopin VSS
XMP Y A VDD VDD pfet_03v3 L=0.28u W=2.5u nf=1 ad='int((nf+1)/2) * W/nf * 0.18u' as='int((nf+2)/2) * W/nf * 0.18u' pd='2*int((nf+1)/2) * (W/nf + 0.18u)'
+ ps='2*int((nf+2)/2) * (W/nf + 0.18u)' nrd='0.18u / W' nrs='0.18u / W' sa=0 sb=0 sd=0 m=1
XMN Y A VSS VSS nfet_03v3 L=0.28u W=1u nf=1 ad='int((nf+1)/2) * W/nf * 0.18u' as='int((nf+2)/2) * W/nf * 0.18u' pd='2*int((nf+1)/2) * (W/nf + 0.18u)'
+ ps='2*int((nf+2)/2) * (W/nf + 0.18u)' nrd='0.18u / W' nrs='0.18u / W' sa=0 sb=0 sd=0 m=1
.ends

* expanding   symbol:  nand2_3v3.sym # of pins=5
** sym_path: design/nand2_3v3.sym
** sch_path: design/nand2_3v3.sch
.subckt nand2_3v3 A B Y VDD VSS
*.ipin A
*.ipin B
*.opin Y
*.iopin VDD
*.iopin VSS
XMPA Y A VDD VDD pfet_03v3 L=0.28u W=2.5u nf=1 ad='int((nf+1)/2) * W/nf * 0.18u' as='int((nf+2)/2) * W/nf * 0.18u' pd='2*int((nf+1)/2) * (W/nf + 0.18u)'
+ ps='2*int((nf+2)/2) * (W/nf + 0.18u)' nrd='0.18u / W' nrs='0.18u / W' sa=0 sb=0 sd=0 m=1
XMPB Y B VDD VDD pfet_03v3 L=0.28u W=2.5u nf=1 ad='int((nf+1)/2) * W/nf * 0.18u' as='int((nf+2)/2) * W/nf * 0.18u' pd='2*int((nf+1)/2) * (W/nf + 0.18u)'
+ ps='2*int((nf+2)/2) * (W/nf + 0.18u)' nrd='0.18u / W' nrs='0.18u / W' sa=0 sb=0 sd=0 m=1
XMNA Y A NMID VSS nfet_03v3 L=0.28u W=2u nf=1 ad='int((nf+1)/2) * W/nf * 0.18u' as='int((nf+2)/2) * W/nf * 0.18u' pd='2*int((nf+1)/2) * (W/nf + 0.18u)'
+ ps='2*int((nf+2)/2) * (W/nf + 0.18u)' nrd='0.18u / W' nrs='0.18u / W' sa=0 sb=0 sd=0 m=1
XMNB NMID B VSS VSS nfet_03v3 L=0.28u W=2u nf=1 ad='int((nf+1)/2) * W/nf * 0.18u' as='int((nf+2)/2) * W/nf * 0.18u' pd='2*int((nf+1)/2) * (W/nf + 0.18u)'
+ ps='2*int((nf+2)/2) * (W/nf + 0.18u)' nrd='0.18u / W' nrs='0.18u / W' sa=0 sb=0 sd=0 m=1
.ends

* expanding   symbol:  nand3_3v3.sym # of pins=6
** sym_path: design/nand3_3v3.sym
** sch_path: design/nand3_3v3.sch
.subckt nand3_3v3 A B C Y VDD VSS
*.ipin A
*.ipin B
*.ipin C
*.opin Y
*.iopin VDD
*.iopin VSS
XMPA Y A VDD VDD pfet_03v3 L=0.28u W=2.5u nf=1 ad='int((nf+1)/2) * W/nf * 0.18u' as='int((nf+2)/2) * W/nf * 0.18u' pd='2*int((nf+1)/2) * (W/nf + 0.18u)'
+ ps='2*int((nf+2)/2) * (W/nf + 0.18u)' nrd='0.18u / W' nrs='0.18u / W' sa=0 sb=0 sd=0 m=1
XMPB Y B VDD VDD pfet_03v3 L=0.28u W=2.5u nf=1 ad='int((nf+1)/2) * W/nf * 0.18u' as='int((nf+2)/2) * W/nf * 0.18u' pd='2*int((nf+1)/2) * (W/nf + 0.18u)'
+ ps='2*int((nf+2)/2) * (W/nf + 0.18u)' nrd='0.18u / W' nrs='0.18u / W' sa=0 sb=0 sd=0 m=1
XMPC Y C VDD VDD pfet_03v3 L=0.28u W=2.5u nf=1 ad='int((nf+1)/2) * W/nf * 0.18u' as='int((nf+2)/2) * W/nf * 0.18u' pd='2*int((nf+1)/2) * (W/nf + 0.18u)'
+ ps='2*int((nf+2)/2) * (W/nf + 0.18u)' nrd='0.18u / W' nrs='0.18u / W' sa=0 sb=0 sd=0 m=1
XMNA Y A NM1 VSS nfet_03v3 L=0.28u W=3u nf=1 ad='int((nf+1)/2) * W/nf * 0.18u' as='int((nf+2)/2) * W/nf * 0.18u' pd='2*int((nf+1)/2) * (W/nf + 0.18u)'
+ ps='2*int((nf+2)/2) * (W/nf + 0.18u)' nrd='0.18u / W' nrs='0.18u / W' sa=0 sb=0 sd=0 m=1
XMNB NM1 B NM2 VSS nfet_03v3 L=0.28u W=3u nf=1 ad='int((nf+1)/2) * W/nf * 0.18u' as='int((nf+2)/2) * W/nf * 0.18u' pd='2*int((nf+1)/2) * (W/nf + 0.18u)'
+ ps='2*int((nf+2)/2) * (W/nf + 0.18u)' nrd='0.18u / W' nrs='0.18u / W' sa=0 sb=0 sd=0 m=1
XMNC NM2 C VSS VSS nfet_03v3 L=0.28u W=3u nf=1 ad='int((nf+1)/2) * W/nf * 0.18u' as='int((nf+2)/2) * W/nf * 0.18u' pd='2*int((nf+1)/2) * (W/nf + 0.18u)'
+ ps='2*int((nf+2)/2) * (W/nf + 0.18u)' nrd='0.18u / W' nrs='0.18u / W' sa=0 sb=0 sd=0 m=1
.ends

* expanding   symbol:  inv2x_3v3.sym # of pins=4
** sym_path: design/inv2x_3v3.sym
** sch_path: design/inv2x_3v3.sch
.subckt inv2x_3v3 A Y VDD VSS
*.ipin A
*.opin Y
*.iopin VDD
*.iopin VSS
XMP Y A VDD VDD pfet_03v3 L=0.28u W=5u nf=1 ad='int((nf+1)/2) * W/nf * 0.18u' as='int((nf+2)/2) * W/nf * 0.18u' pd='2*int((nf+1)/2) * (W/nf + 0.18u)'
+ ps='2*int((nf+2)/2) * (W/nf + 0.18u)' nrd='0.18u / W' nrs='0.18u / W' sa=0 sb=0 sd=0 m=1
XMN Y A VSS VSS nfet_03v3 L=0.28u W=2u nf=1 ad='int((nf+1)/2) * W/nf * 0.18u' as='int((nf+2)/2) * W/nf * 0.18u' pd='2*int((nf+1)/2) * (W/nf + 0.18u)'
+ ps='2*int((nf+2)/2) * (W/nf + 0.18u)' nrd='0.18u / W' nrs='0.18u / W' sa=0 sb=0 sd=0 m=1
.ends

* expanding   symbol:  dff_tg_3v3.sym # of pins=6
** sym_path: design/dff_tg_3v3.sym
** sch_path: design/dff_tg_3v3.sch
.subckt dff_tg_3v3 D CK Q QB VDD VSS
*.ipin D
*.ipin CK
*.opin Q
*.opin QB
*.iopin VDD
*.iopin VSS
XICKB CK CKB VDD VSS inv_3v3
XICKBB CKB CKBB VDD VSS inv_3v3
XTGMI D NM CKB CKBB VDD VSS tgate_3v3
XIA NM NMA VDD VSS inv_3v3
XIB NMA NMB VDD VSS inv_3v3
XTGMF NMB NM CKBB CKB VDD VSS tgate_3v3
XTGSI NMA NS CKBB CKB VDD VSS tgate_3v3
XIC NS Q VDD VSS inv_3v3
XID Q QB VDD VSS inv_3v3
XTGSF QB NS CKB CKBB VDD VSS tgate_3v3
.ends

* expanding   symbol:  xor2_3v3.sym # of pins=5
** sym_path: design/xor2_3v3.sym
** sch_path: design/xor2_3v3.sch
.subckt xor2_3v3 A B Y VDD VSS
*.ipin A
*.ipin B
*.opin Y
*.iopin VDD
*.iopin VSS
XG1 A B N1 VDD VSS nand2_3v3
XG2 A N1 N2 VDD VSS nand2_3v3
XG3 B N1 N3 VDD VSS nand2_3v3
XG4 N2 N3 Y VDD VSS nand2_3v3
.ends

* expanding   symbol:  delaywin_3v3.sym # of pins=4
** sym_path: design/delaywin_3v3.sym
** sch_path: design/delaywin_3v3.sch
.subckt delaywin_3v3 A Y VDD VSS
*.ipin A
*.opin Y
*.iopin VDD
*.iopin VSS
XI1 A D1 VDD VSS inv_3v3
XMC1 VSS D1 VSS VSS nfet_03v3 L=2u W=8u nf=1 ad='int((nf+1)/2) * W/nf * 0.18u' as='int((nf+2)/2) * W/nf * 0.18u' pd='2*int((nf+1)/2) * (W/nf + 0.18u)'
+ ps='2*int((nf+2)/2) * (W/nf + 0.18u)' nrd='0.18u / W' nrs='0.18u / W' sa=0 sb=0 sd=0 m=1
XI2 D1 D2 VDD VSS inv_3v3
XMC2 VSS D2 VSS VSS nfet_03v3 L=2u W=8u nf=1 ad='int((nf+1)/2) * W/nf * 0.18u' as='int((nf+2)/2) * W/nf * 0.18u' pd='2*int((nf+1)/2) * (W/nf + 0.18u)'
+ ps='2*int((nf+2)/2) * (W/nf + 0.18u)' nrd='0.18u / W' nrs='0.18u / W' sa=0 sb=0 sd=0 m=1
XI3 D2 D3 VDD VSS inv_3v3
XMC3 VSS D3 VSS VSS nfet_03v3 L=2u W=8u nf=1 ad='int((nf+1)/2) * W/nf * 0.18u' as='int((nf+2)/2) * W/nf * 0.18u' pd='2*int((nf+1)/2) * (W/nf + 0.18u)'
+ ps='2*int((nf+2)/2) * (W/nf + 0.18u)' nrd='0.18u / W' nrs='0.18u / W' sa=0 sb=0 sd=0 m=1
XI4 D3 Y VDD VSS inv_3v3
XMC4 VSS Y VSS VSS nfet_03v3 L=2u W=8u nf=1 ad='int((nf+1)/2) * W/nf * 0.18u' as='int((nf+2)/2) * W/nf * 0.18u' pd='2*int((nf+1)/2) * (W/nf + 0.18u)'
+ ps='2*int((nf+2)/2) * (W/nf + 0.18u)' nrd='0.18u / W' nrs='0.18u / W' sa=0 sb=0 sd=0 m=1
.ends

* expanding   symbol:  schmitt_3v3.sym # of pins=4
** sym_path: design/schmitt_3v3.sym
** sch_path: design/schmitt_3v3.sch
.subckt schmitt_3v3 A Y VDD VSS
*.ipin A
*.opin Y
*.iopin VDD
*.iopin VSS
XMP1 P1 A VDD VDD pfet_03v3 L=0.28u W=2.5u nf=1 ad='int((nf+1)/2) * W/nf * 0.18u' as='int((nf+2)/2) * W/nf * 0.18u' pd='2*int((nf+1)/2) * (W/nf + 0.18u)'
+ ps='2*int((nf+2)/2) * (W/nf + 0.18u)' nrd='0.18u / W' nrs='0.18u / W' sa=0 sb=0 sd=0 m=1
XMP2 Y A P1 VDD pfet_03v3 L=0.28u W=2.5u nf=1 ad='int((nf+1)/2) * W/nf * 0.18u' as='int((nf+2)/2) * W/nf * 0.18u' pd='2*int((nf+1)/2) * (W/nf + 0.18u)'
+ ps='2*int((nf+2)/2) * (W/nf + 0.18u)' nrd='0.18u / W' nrs='0.18u / W' sa=0 sb=0 sd=0 m=1
XMP3 VSS Y P1 VDD pfet_03v3 L=0.28u W=1.2u nf=1 ad='int((nf+1)/2) * W/nf * 0.18u' as='int((nf+2)/2) * W/nf * 0.18u' pd='2*int((nf+1)/2) * (W/nf + 0.18u)'
+ ps='2*int((nf+2)/2) * (W/nf + 0.18u)' nrd='0.18u / W' nrs='0.18u / W' sa=0 sb=0 sd=0 m=1
XMN1 N1 A VSS VSS nfet_03v3 L=0.28u W=1u nf=1 ad='int((nf+1)/2) * W/nf * 0.18u' as='int((nf+2)/2) * W/nf * 0.18u' pd='2*int((nf+1)/2) * (W/nf + 0.18u)'
+ ps='2*int((nf+2)/2) * (W/nf + 0.18u)' nrd='0.18u / W' nrs='0.18u / W' sa=0 sb=0 sd=0 m=1
XMN2 Y A N1 VSS nfet_03v3 L=0.28u W=1u nf=1 ad='int((nf+1)/2) * W/nf * 0.18u' as='int((nf+2)/2) * W/nf * 0.18u' pd='2*int((nf+1)/2) * (W/nf + 0.18u)'
+ ps='2*int((nf+2)/2) * (W/nf + 0.18u)' nrd='0.18u / W' nrs='0.18u / W' sa=0 sb=0 sd=0 m=1
XMN3 VDD Y N1 VSS nfet_03v3 L=0.28u W=0.5u nf=1 ad='int((nf+1)/2) * W/nf * 0.18u' as='int((nf+2)/2) * W/nf * 0.18u' pd='2*int((nf+1)/2) * (W/nf + 0.18u)'
+ ps='2*int((nf+2)/2) * (W/nf + 0.18u)' nrd='0.18u / W' nrs='0.18u / W' sa=0 sb=0 sd=0 m=1
.ends

* expanding   symbol:  edgedet.sym # of pins=4
** sym_path: design/edgedet.sym
** sch_path: design/edgedet.sch
.subckt edgedet X PULSE VDD VSS
*.ipin X
*.opin PULSE
*.iopin VDD
*.iopin VSS
xi1 X D1 VDD VSS pfdcp_inv_3v3
xi2 D1 D2 VDD VSS pfdcp_inv_3v3
xi3 D2 D3 VDD VSS pfdcp_inv_3v3
xi4 D3 D4 VDD VSS pfdcp_inv_3v3
xi5 D4 D5 VDD VSS pfdcp_inv_3v3
xnd X D5 NN VDD VSS pfdcp_nand2_3v3
xi6 NN PULSE VDD VSS pfdcp_inv_3v3
.ends

* expanding   symbol:  pfdcp_inv_3v3.sym # of pins=4
** sym_path: design/pfdcp_inv_3v3.sym
** sch_path: design/pfdcp_inv_3v3.sch
.subckt pfdcp_inv_3v3 A Y VDD VSS
*.ipin A
*.opin Y
*.iopin VDD
*.iopin VSS
XMP Y A VDD VDD pfet_03v3 L=0.3u W=1.5u nf=1 ad='int((nf+1)/2) * W/nf * 0.18u' as='int((nf+2)/2) * W/nf * 0.18u' pd='2*int((nf+1)/2) * (W/nf + 0.18u)'
+ ps='2*int((nf+2)/2) * (W/nf + 0.18u)' nrd='0.18u / W' nrs='0.18u / W' sa=0 sb=0 sd=0 m=1
XMN Y A VSS VSS nfet_03v3 L=0.3u W=0.5u nf=1 ad='int((nf+1)/2) * W/nf * 0.18u' as='int((nf+2)/2) * W/nf * 0.18u' pd='2*int((nf+1)/2) * (W/nf + 0.18u)'
+ ps='2*int((nf+2)/2) * (W/nf + 0.18u)' nrd='0.18u / W' nrs='0.18u / W' sa=0 sb=0 sd=0 m=1
.ends

* expanding   symbol:  srlatch.sym # of pins=6
** sym_path: design/srlatch.sym
** sch_path: design/srlatch.sch
.subckt srlatch SB RB Q QB VDD VSS
*.ipin SB
*.ipin RB
*.opin Q
*.opin QB
*.iopin VDD
*.iopin VSS
xn1 SB QB Q VDD VSS pfdcp_nand2_3v3
xn2 RB Q QB VDD VSS pfdcp_nand2_3v3
.ends

* expanding   symbol:  pfdcp_nand2_3v3.sym # of pins=5
** sym_path: design/pfdcp_nand2_3v3.sym
** sch_path: design/pfdcp_nand2_3v3.sch
.subckt pfdcp_nand2_3v3 A B Y VDD VSS
*.ipin A
*.ipin B
*.opin Y
*.iopin VDD
*.iopin VSS
XMP1 Y A VDD VDD pfet_03v3 L=0.3u W=1.5u nf=1 ad='int((nf+1)/2) * W/nf * 0.18u' as='int((nf+2)/2) * W/nf * 0.18u' pd='2*int((nf+1)/2) * (W/nf + 0.18u)'
+ ps='2*int((nf+2)/2) * (W/nf + 0.18u)' nrd='0.18u / W' nrs='0.18u / W' sa=0 sb=0 sd=0 m=1
XMP2 Y B VDD VDD pfet_03v3 L=0.3u W=1.5u nf=1 ad='int((nf+1)/2) * W/nf * 0.18u' as='int((nf+2)/2) * W/nf * 0.18u' pd='2*int((nf+1)/2) * (W/nf + 0.18u)'
+ ps='2*int((nf+2)/2) * (W/nf + 0.18u)' nrd='0.18u / W' nrs='0.18u / W' sa=0 sb=0 sd=0 m=1
XMN1 Y A NI VSS nfet_03v3 L=0.3u W=1u nf=1 ad='int((nf+1)/2) * W/nf * 0.18u' as='int((nf+2)/2) * W/nf * 0.18u' pd='2*int((nf+1)/2) * (W/nf + 0.18u)'
+ ps='2*int((nf+2)/2) * (W/nf + 0.18u)' nrd='0.18u / W' nrs='0.18u / W' sa=0 sb=0 sd=0 m=1
XMN2 NI B VSS VSS nfet_03v3 L=0.3u W=1u nf=1 ad='int((nf+1)/2) * W/nf * 0.18u' as='int((nf+2)/2) * W/nf * 0.18u' pd='2*int((nf+1)/2) * (W/nf + 0.18u)'
+ ps='2*int((nf+2)/2) * (W/nf + 0.18u)' nrd='0.18u / W' nrs='0.18u / W' sa=0 sb=0 sd=0 m=1
.ends

* expanding   symbol:  cp_leg_n.sym # of pins=6
** sym_path: design/cp_leg_n.sym
** sch_path: design/cp_leg_n.sch
.subckt cp_leg_n VBN VCASCN EN ENB TAIL VSS
*.ipin VBN
*.ipin VCASCN
*.ipin EN
*.ipin ENB
*.iopin TAIL
*.iopin VSS
XMEN BG EN VBN VSS nfet_03v3 L=0.3u W=1u nf=1 ad='int((nf+1)/2) * W/nf * 0.18u' as='int((nf+2)/2) * W/nf * 0.18u' pd='2*int((nf+1)/2) * (W/nf + 0.18u)'
+ ps='2*int((nf+2)/2) * (W/nf + 0.18u)' nrd='0.18u / W' nrs='0.18u / W' sa=0 sb=0 sd=0 m=1
XMDIS BG ENB VSS VSS nfet_03v3 L=0.3u W=1u nf=1 ad='int((nf+1)/2) * W/nf * 0.18u' as='int((nf+2)/2) * W/nf * 0.18u' pd='2*int((nf+1)/2) * (W/nf + 0.18u)'
+ ps='2*int((nf+2)/2) * (W/nf + 0.18u)' nrd='0.18u / W' nrs='0.18u / W' sa=0 sb=0 sd=0 m=1
XMBOT MID BG VSS VSS nfet_03v3 L=1u W=4u nf=1 ad='int((nf+1)/2) * W/nf * 0.18u' as='int((nf+2)/2) * W/nf * 0.18u' pd='2*int((nf+1)/2) * (W/nf + 0.18u)'
+ ps='2*int((nf+2)/2) * (W/nf + 0.18u)' nrd='0.18u / W' nrs='0.18u / W' sa=0 sb=0 sd=0 m=1
XMCASC TAIL VCASCN MID VSS nfet_03v3 L=1u W=4u nf=1 ad='int((nf+1)/2) * W/nf * 0.18u' as='int((nf+2)/2) * W/nf * 0.18u' pd='2*int((nf+1)/2) * (W/nf + 0.18u)'
+ ps='2*int((nf+2)/2) * (W/nf + 0.18u)' nrd='0.18u / W' nrs='0.18u / W' sa=0 sb=0 sd=0 m=1
.ends

* expanding   symbol:  cp_leg_p.sym # of pins=6
** sym_path: design/cp_leg_p.sym
** sch_path: design/cp_leg_p.sch
.subckt cp_leg_p VBP VCASCP EN ENB TAIL VDD
*.ipin VBP
*.ipin VCASCP
*.ipin EN
*.ipin ENB
*.iopin TAIL
*.iopin VDD
XMEN BG ENB VBP VDD pfet_03v3 L=0.3u W=1u nf=1 ad='int((nf+1)/2) * W/nf * 0.18u' as='int((nf+2)/2) * W/nf * 0.18u' pd='2*int((nf+1)/2) * (W/nf + 0.18u)'
+ ps='2*int((nf+2)/2) * (W/nf + 0.18u)' nrd='0.18u / W' nrs='0.18u / W' sa=0 sb=0 sd=0 m=1
XMDIS BG EN VDD VDD pfet_03v3 L=0.3u W=1u nf=1 ad='int((nf+1)/2) * W/nf * 0.18u' as='int((nf+2)/2) * W/nf * 0.18u' pd='2*int((nf+1)/2) * (W/nf + 0.18u)'
+ ps='2*int((nf+2)/2) * (W/nf + 0.18u)' nrd='0.18u / W' nrs='0.18u / W' sa=0 sb=0 sd=0 m=1
XMTOP MID BG VDD VDD pfet_03v3 L=1u W=12u nf=1 ad='int((nf+1)/2) * W/nf * 0.18u' as='int((nf+2)/2) * W/nf * 0.18u' pd='2*int((nf+1)/2) * (W/nf + 0.18u)'
+ ps='2*int((nf+2)/2) * (W/nf + 0.18u)' nrd='0.18u / W' nrs='0.18u / W' sa=0 sb=0 sd=0 m=1
XMCASC TAIL VCASCP MID VDD pfet_03v3 L=1u W=12u nf=1 ad='int((nf+1)/2) * W/nf * 0.18u' as='int((nf+2)/2) * W/nf * 0.18u' pd='2*int((nf+1)/2) * (W/nf + 0.18u)'
+ ps='2*int((nf+2)/2) * (W/nf + 0.18u)' nrd='0.18u / W' nrs='0.18u / W' sa=0 sb=0 sd=0 m=1
.ends

* expanding   symbol:  cp_dumpbuf.sym # of pins=6
** sym_path: design/cp_dumpbuf.sym
** sch_path: design/cp_dumpbuf.sch
.subckt cp_dumpbuf VREF VBN VBP VDUMP VDD VSS
*.ipin VREF
*.ipin VBN
*.ipin VBP
*.iopin VDUMP
*.iopin VDD
*.iopin VSS
XMTN NSRC VBN VSS VSS nfet_03v3 L=1u W=16u nf=1 ad='int((nf+1)/2) * W/nf * 0.18u' as='int((nf+2)/2) * W/nf * 0.18u' pd='2*int((nf+1)/2) * (W/nf + 0.18u)'
+ ps='2*int((nf+2)/2) * (W/nf + 0.18u)' nrd='0.18u / W' nrs='0.18u / W' sa=0 sb=0 sd=0 m=1
XMN1 NDA VREF NSRC VSS nfet_03v3 L=1u W=16u nf=1 ad='int((nf+1)/2) * W/nf * 0.18u' as='int((nf+2)/2) * W/nf * 0.18u' pd='2*int((nf+1)/2) * (W/nf + 0.18u)'
+ ps='2*int((nf+2)/2) * (W/nf + 0.18u)' nrd='0.18u / W' nrs='0.18u / W' sa=0 sb=0 sd=0 m=1
XMN2 VDUMP VDUMP NSRC VSS nfet_03v3 L=1u W=16u nf=1 ad='int((nf+1)/2) * W/nf * 0.18u' as='int((nf+2)/2) * W/nf * 0.18u' pd='2*int((nf+1)/2) * (W/nf + 0.18u)'
+ ps='2*int((nf+2)/2) * (W/nf + 0.18u)' nrd='0.18u / W' nrs='0.18u / W' sa=0 sb=0 sd=0 m=1
XMN3 NDA NDA VDD VDD pfet_03v3 L=1u W=24u nf=1 ad='int((nf+1)/2) * W/nf * 0.18u' as='int((nf+2)/2) * W/nf * 0.18u' pd='2*int((nf+1)/2) * (W/nf + 0.18u)'
+ ps='2*int((nf+2)/2) * (W/nf + 0.18u)' nrd='0.18u / W' nrs='0.18u / W' sa=0 sb=0 sd=0 m=1
XMN4 VDUMP NDA VDD VDD pfet_03v3 L=1u W=24u nf=1 ad='int((nf+1)/2) * W/nf * 0.18u' as='int((nf+2)/2) * W/nf * 0.18u' pd='2*int((nf+1)/2) * (W/nf + 0.18u)'
+ ps='2*int((nf+2)/2) * (W/nf + 0.18u)' nrd='0.18u / W' nrs='0.18u / W' sa=0 sb=0 sd=0 m=1
XMTP PSRC VBP VDD VDD pfet_03v3 L=1u W=48u nf=1 ad='int((nf+1)/2) * W/nf * 0.18u' as='int((nf+2)/2) * W/nf * 0.18u' pd='2*int((nf+1)/2) * (W/nf + 0.18u)'
+ ps='2*int((nf+2)/2) * (W/nf + 0.18u)' nrd='0.18u / W' nrs='0.18u / W' sa=0 sb=0 sd=0 m=1
XMP1 PDA VREF PSRC PSRC pfet_03v3 L=1u W=48u nf=1 ad='int((nf+1)/2) * W/nf * 0.18u' as='int((nf+2)/2) * W/nf * 0.18u' pd='2*int((nf+1)/2) * (W/nf + 0.18u)'
+ ps='2*int((nf+2)/2) * (W/nf + 0.18u)' nrd='0.18u / W' nrs='0.18u / W' sa=0 sb=0 sd=0 m=1
XMP2 VDUMP VDUMP PSRC PSRC pfet_03v3 L=1u W=48u nf=1 ad='int((nf+1)/2) * W/nf * 0.18u' as='int((nf+2)/2) * W/nf * 0.18u' pd='2*int((nf+1)/2) * (W/nf + 0.18u)'
+ ps='2*int((nf+2)/2) * (W/nf + 0.18u)' nrd='0.18u / W' nrs='0.18u / W' sa=0 sb=0 sd=0 m=1
XMP3 PDA PDA VSS VSS nfet_03v3 L=1u W=16u nf=1 ad='int((nf+1)/2) * W/nf * 0.18u' as='int((nf+2)/2) * W/nf * 0.18u' pd='2*int((nf+1)/2) * (W/nf + 0.18u)'
+ ps='2*int((nf+2)/2) * (W/nf + 0.18u)' nrd='0.18u / W' nrs='0.18u / W' sa=0 sb=0 sd=0 m=1
XMP4 VDUMP PDA VSS VSS nfet_03v3 L=1u W=16u nf=1 ad='int((nf+1)/2) * W/nf * 0.18u' as='int((nf+2)/2) * W/nf * 0.18u' pd='2*int((nf+1)/2) * (W/nf + 0.18u)'
+ ps='2*int((nf+2)/2) * (W/nf + 0.18u)' nrd='0.18u / W' nrs='0.18u / W' sa=0 sb=0 sd=0 m=1
.ends

* expanding   symbol:  tgate_3v3.sym # of pins=6
** sym_path: design/tgate_3v3.sym
** sch_path: design/tgate_3v3.sch
.subckt tgate_3v3 A Y GN GP VDD VSS
*.iopin A
*.iopin Y
*.ipin GN
*.ipin GP
*.iopin VDD
*.iopin VSS
XMP Y GP A VDD pfet_03v3 L=0.28u W=2.5u nf=1 ad='int((nf+1)/2) * W/nf * 0.18u' as='int((nf+2)/2) * W/nf * 0.18u' pd='2*int((nf+1)/2) * (W/nf + 0.18u)'
+ ps='2*int((nf+2)/2) * (W/nf + 0.18u)' nrd='0.18u / W' nrs='0.18u / W' sa=0 sb=0 sd=0 m=1
XMN A GN Y VSS nfet_03v3 L=0.28u W=1u nf=1 ad='int((nf+1)/2) * W/nf * 0.18u' as='int((nf+2)/2) * W/nf * 0.18u' pd='2*int((nf+1)/2) * (W/nf + 0.18u)'
+ ps='2*int((nf+2)/2) * (W/nf + 0.18u)' nrd='0.18u / W' nrs='0.18u / W' sa=0 sb=0 sd=0 m=1
.ends

* gf180-pll :: output-range :: closed-loop output-band coverage testbench (#12)
*
* DUT: `pll_top` -- the SAME whole-PLL DUT as sim/lock-time, sim/pll-top-smoke
* and sim/supply-sensitivity: design/pll_top.sch, netlisted by
* design/netlist.sh into design/netlist/pll_top.spice and prepended to this
* fragment by sim/lib/pll_top_dut.sh (#52).  This bench answers a different
* question than lock-time: not "how long does the loop take to lock", but
* "does the loop reach the ratified output-band EDGE frequencies at all, and
* with how much control-voltage headroom to the usable 0.9-2.7 V window" --
* complementing (not re-deriving) #8's open-loop vco-tuning-range
* characterization, which is what this bench's initial condition and target
* selection are taken from (see run.sh).
*
* MIGRATED FROM sim/lib/assemble_closed_loop.sh (#159), in lockstep with
* sim/lock-time and for the same reason: the loop's top-level wiring now
* comes from design/pll_top.sch instead of from this testbench's own instance
* list, so no two campaigns can disagree about the connectivity without the
* schematic diff showing it.  Every record already in
* sim/output-range/records/ was taken against the older assembly and names it
* in its own Netlist provenance field; those records are append-only evidence
* and are not restated or reinterpreted here.  See
* sim/lock-time/testbench/tb_lock_time.sp's header for the itemised list of
* what changed -- this deck took exactly the same changes.
*
* Same net names, stimulus and topology as tb_lock_time.sp; see that file's
* header for the full description.
*
* Expects from the generated header (sim/lib/simenv.sh): the same param set
* as tb_lock_time.sp (vsup, fref, b*_code, cpb*_code, sel*_code, p*_code,
* iunit, vctrl_ic, t_force, tstep, tstop, tmax, lockthresh). vctrl_ic here is
* NOT cold-start-vs-re-lock -- it is run.sh's best open-loop estimate of the
* locked Vctrl (from sim/vco-tuning-range's own measured f(Vctrl) table),
* used ONLY to keep the required simulated transient short enough to be
* tractable (see this record's Methodology field): the loop still closes and
* settles on its own, this just avoids re-proving cold-start slewing, which
* is lock-time's (#12) job, not this bench's.

*------------------------------------------------------------------ supplies
vvdd    vdd     0 dc 'vsup'
vvddvco vdd_vco 0 dc 'vsup'
vvdddiv vdd_div 0 dc 'vsup'
vgndvco gnd_vco 0 dc 0
vvss    vss     0 dc 0

*----------------------------------------------------------- reference clock
vref ref 0 pulse(0 'vsup' 20n 200p 200p '0.5/fref-200p' '1/fref')

*----------------------------------------------------- static configuration
* Encoded by sim/lib/pll_top_dut.sh (cloop_band_params / cloop_trim_params /
* cloop_divider_params), not by this deck -- see tb_lock_time.sp's header.
vb0   b0   0 dc 'vsup*b0_code'
vb1   b1   0 dc 'vsup*b1_code'
vb2   b2   0 dc 'vsup*b2_code'
vcpb0 cpb0 0 dc 'vsup*cpb0_code'
vcpb1 cpb1 0 dc 'vsup*cpb1_code'
vp0   p0   0 dc 'vsup*p0_code'
vp1   p1   0 dc 'vsup*p1_code'
vp2   p2   0 dc 'vsup*p2_code'
vp3   p3   0 dc 'vsup*p3_code'
vp4   p4   0 dc 'vsup*p4_code'
vp5   p5   0 dc 'vsup*p5_code'
vs0   sel0 0 dc 'vsup*sel0_code'
vs1   sel1 0 dc 'vsup*sel1_code'
vs2   sel2 0 dc 'vsup*sel2_code'
vs3   sel3 0 dc 'vsup*sel3_code'
vs4   sel4 0 dc 'vsup*sel4_code'
vs5   sel5 0 dc 'vsup*sel5_code'

iibn vdd ibn dc 'iunit'
iicn vdd icn dc 'iunit'
iibp ibp 0 dc 'iunit'
iicp icp 0 dc 'iunit'

*--------------------------------------------------------------------- DUT
* Generated by sim/lib/pll_top_dut.sh's `cloop_instance`.
xdut ref b0 b1 b2 cpb0 cpb1 p0 p1 p2 p3 p4 p5 sel0 sel1 sel2 sel3 sel4 sel5
+ ibn icn ibp icp clk divout fb lock vctrl vdd vdd_vco gnd_vco vdd_div vss
+ pll_top

.ic v(xdut.xvco.y1)=0 v(xdut.xvco.y2)='vsup' v(xdut.xvco.y3)=0
+ v(xdut.xvco.y4)='vsup' v(xdut.xvco.y5)=0

* Released clamp seeding VCTRL near run.sh's open-loop estimate of the
* locked value (see header comment above and this record's Methodology) --
* same mechanism as tb_lock_time.sp.
vsetv vsetnode 0 dc 'vctrl_ic'
* Release transition sized as a multiple of the internal-timestep ceiling
* (#65) -- same fix as tb_lock_time.sp's identical mechanism, applied here
* preemptively for the same root cause: at the OLD 100 ps tr/tf (equal to
* the 100 ps ceiling), the switch's Ron(10)/Roff(1G) discontinuity spans
* exactly one ceiling-sized step, which sim/lock-time's cold-start row
* (vctrl_ic=0.9V, at a rail) showed ngspice cannot resolve -- "Timestep too
* small", 100% reproducible, independent of corner or host load. This bench
* was NOT observed to reproduce the crash at its one checked point
* (typical/27C/3.30V, `lo` edge, vctrl_ic ~1.68V mid-window rather than at a
* rail) before this fix landed, but shares the identical model/mechanism, so
* the fix is applied defensively rather than waiting for a corner where the
* discontinuity happens to be sharp enough to fail. See this campaign's
* sibling investigation record (sim/lock-time) for the full root-cause.
vsctrl sctrl 0 pulse('vsup' 0 't_force' '10*tmax' '10*tmax' '2*tstop' '4*tstop')
sforce vctrl vsetnode sctrl 0 SWFORCE
.model SWFORCE SW(Ron=10 Roff=1G Vt='vsup/2' Vh=0)

* rshunt / itl4 are REQUIRED on this DUT and are solver knobs only -- every
* convergence TOLERANCE is this campaign's own, unchanged from before #159,
* so the converged solution is the one this campaign has always reported.
* See tb_lock_time.sp's identical `.options` note for the bisection that
* established rshunt is not optional here (without it the migrated deck
* aborts inside the SWFORCE release ramp on the loop filter's nonlinear
* moscap branch) and for the floating-cascode-node reason sim/pfd-deadzone,
* sim/pll-top-smoke and sim/supply-sensitivity all carry the same 1 Tohm
* shunt.
.options rshunt=1e12 itl4=200 reltol=1e-3 abstol=1e-9 vntol=1e-4 chgtol=1e-13

* The transient is issued ONCE, from the `.control` block at the bottom,
* rather than from a top-level `.tran` card that ngspice batch mode would
* then re-run a second time -- see tb_lock_time.sp's identical note, and
* sim/pll-top-smoke/testbench/tb_pll_smoke.sp, which documented the
* mechanism this campaign's own records had reported as ngspice
* "re-entering its own analysis path" after printing complete measurements.
*
* The 4th transient argument (tmax) is LOAD-BEARING -- see tb_lock_time.sp's
* identical note and sim/lib/simenv.sh's SIMENV_CLOSED_LOOP_TMAX. This bench
* was the worse of the two violators before #65: with the ceiling defaulting
* to the print step {tstep} = 1/(50*f_out), the 10 MHz `lo` edge ran at a 2 ns
* internal ceiling, and 91% of its measured internal steps were LONGER than
* the PFD's entire 0.33-0.39 ns set pulse.
.csparam c_tstep={tstep}
.csparam c_tstop={tstop}
.csparam c_tmax={tmax}
.csparam c_nstop={nstop}

*------------------------------------------------------------- measurements
* Same real lock_detector criterion as tb_lock_time.sp -- this bench also
* reports whether the loop actually LOCKED at the target frequency, not just
* that Vctrl landed somewhere plausible.
.measure tran t_lock_last_rise when v(lock)='lockthresh' rise=last
.measure tran lock_at_end find v(lock) at='tstop-1p'
* The control-voltage margin measurement this campaign exists for.
.measure tran vctrl_final find v(vctrl) at='tstop-1p'

* PFD DN-branch integration guard (#69) -- see tb_lock_time.sp's identical
* measure for the full rationale.  This campaign is where the guard was
* validated: at the pre-#75 ceiling the `lo` edge derived a 2.0 ns internal
* timestep from its 10 MHz output (~6x the PFD's 0.33-0.39 ns set pulse) and
* this measure read 6.6e-7 V against a 9.9e-4 V floor -- the DN branch was not
* asserting at all, while the campaign's own verdict table showed nothing
* unusual.  run.sh scores it three-valued (PASS / FAIL / SUSPECT / ERROR).
* DN is internal to pll_top since #159, hence the hierarchical reference.
.measure tran dn_lvl avg v(xdut.dn) from='0.9*tstop' to='tstop-1p'

* Full-transient waveform capture -- see tb_lock_time.sp's header comment
* above the identical `.control` block for the rationale (#49's Vctrl-anomaly
* prerequisite; no extra analysis cost, left on unconditionally).
* ---- #168 stall-trace instrumentation (stall_trace.sh) ----
* The ONLY difference from the campaign deck. `tran` is issued with the
* identical arguments; the `stop after` breakpoint bounds the number of
* accepted timepoints instead of the window, so the trajectory is the
* campaign run's own. `write` dumps every vector, including `time`, so the
* achieved internal timestep can be read off directly.
.control
  set noaskquit
  set filetype=ascii
  stop after $&c_nstop
  tran $&c_tstep $&c_tstop 0 $&c_tmax
  echo STALL_TRACE: stopped after $&c_nstop accepted timepoints
  write trace.raw all
.endc
