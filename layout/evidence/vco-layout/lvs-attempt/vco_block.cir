* Extracted by KLayout with GF180MCU LVS runset on : 10/09/2026 15:07

.SUBCKT vco_block B0 B1 B2
+ BUF1.NB1|BUF2.NB2|BUF3.CLK|CLK|GND_VCO|S1.Y|S2.Y|S3.Y|S4.Y|S5.Y|VBN|VBP0|VDD_VCO|Y1|Y2|Y3|Y4|Y5|Y5_CLK_IN
+ GND_VCO NC NOFF NVI VBP|VDD_VCO VCTRL VDD_VCO
M$1
+ BUF1.NB1|BUF2.NB2|BUF3.CLK|CLK|GND_VCO|S1.Y|S2.Y|S3.Y|S4.Y|S5.Y|VBN|VBP0|VDD_VCO|Y1|Y2|Y3|Y4|Y5|Y5_CLK_IN
+ GND_VCO
+ BUF1.NB1|BUF2.NB2|BUF3.CLK|CLK|GND_VCO|S1.Y|S2.Y|S3.Y|S4.Y|S5.Y|VBN|VBP0|VDD_VCO|Y1|Y2|Y3|Y4|Y5|Y5_CLK_IN
+ BUF1.NB1|BUF2.NB2|BUF3.CLK|CLK|GND_VCO|S1.Y|S2.Y|S3.Y|S4.Y|S5.Y|VBN|VBP0|VDD_VCO|Y1|Y2|Y3|Y4|Y5|Y5_CLK_IN
+ pfet_03v3 L=20U W=0.22U AS=0.53P AD=0.53P PS=3.84U PD=3.84U
M$2
+ BUF1.NB1|BUF2.NB2|BUF3.CLK|CLK|GND_VCO|S1.Y|S2.Y|S3.Y|S4.Y|S5.Y|VBN|VBP0|VDD_VCO|Y1|Y2|Y3|Y4|Y5|Y5_CLK_IN
+ BUF1.NB1|BUF2.NB2|BUF3.CLK|CLK|GND_VCO|S1.Y|S2.Y|S3.Y|S4.Y|S5.Y|VBN|VBP0|VDD_VCO|Y1|Y2|Y3|Y4|Y5|Y5_CLK_IN
+ BUF1.NB1|BUF2.NB2|BUF3.CLK|CLK|GND_VCO|S1.Y|S2.Y|S3.Y|S4.Y|S5.Y|VBN|VBP0|VDD_VCO|Y1|Y2|Y3|Y4|Y5|Y5_CLK_IN
+ BUF1.NB1|BUF2.NB2|BUF3.CLK|CLK|GND_VCO|S1.Y|S2.Y|S3.Y|S4.Y|S5.Y|VBN|VBP0|VDD_VCO|Y1|Y2|Y3|Y4|Y5|Y5_CLK_IN
+ pfet_03v3 L=1U W=82.5U AS=123.75P AD=123.75P PS=186U PD=186U
M$9 VDD_VCO
+ BUF1.NB1|BUF2.NB2|BUF3.CLK|CLK|GND_VCO|S1.Y|S2.Y|S3.Y|S4.Y|S5.Y|VBN|VBP0|VDD_VCO|Y1|Y2|Y3|Y4|Y5|Y5_CLK_IN
+ \$36 VDD_VCO pfet_03v3 L=1U W=26.5U AS=39.75P AD=39.75P PS=59U PD=59U
M$10 VDD_VCO \$52 \$36 VDD_VCO pfet_03v3 L=1U W=17.22U AS=25.83P AD=25.83P
+ PS=40.44U PD=40.44U
M$11 VDD_VCO B0 \$35 VDD_VCO pfet_03v3 L=0.28U W=2U AS=3P AD=3P PS=7U PD=7U
M$14
+ BUF1.NB1|BUF2.NB2|BUF3.CLK|CLK|GND_VCO|S1.Y|S2.Y|S3.Y|S4.Y|S5.Y|VBN|VBP0|VDD_VCO|Y1|Y2|Y3|Y4|Y5|Y5_CLK_IN
+ \$35 \$52 VDD_VCO pfet_03v3 L=0.5U W=2U AS=3P AD=3P PS=7U PD=7U
M$15 VDD_VCO B0 \$52 VDD_VCO pfet_03v3 L=0.5U W=2U AS=3P AD=3P PS=7U PD=7U
M$16 VDD_VCO B1 \$34 VDD_VCO pfet_03v3 L=0.28U W=2U AS=3P AD=3P PS=7U PD=7U
M$17 VDD_VCO \$37 \$37 VDD_VCO pfet_03v3 L=1U W=20U AS=30P AD=30P PS=43U PD=43U
M$18 VDD_VCO B2 \$38 VDD_VCO pfet_03v3 L=0.28U W=2U AS=3P AD=3P PS=7U PD=7U
M$19 \$37 \$38 \$53 VDD_VCO pfet_03v3 L=0.5U W=2U AS=3P AD=3P PS=7U PD=7U
M$20 VDD_VCO B2 \$53 VDD_VCO pfet_03v3 L=0.5U W=2U AS=3P AD=3P PS=7U PD=7U
M$21
+ BUF1.NB1|BUF2.NB2|BUF3.CLK|CLK|GND_VCO|S1.Y|S2.Y|S3.Y|S4.Y|S5.Y|VBN|VBP0|VDD_VCO|Y1|Y2|Y3|Y4|Y5|Y5_CLK_IN
+ \$53
+ BUF1.NB1|BUF2.NB2|BUF3.CLK|CLK|GND_VCO|S1.Y|S2.Y|S3.Y|S4.Y|S5.Y|VBN|VBP0|VDD_VCO|Y1|Y2|Y3|Y4|Y5|Y5_CLK_IN
+ BUF1.NB1|BUF2.NB2|BUF3.CLK|CLK|GND_VCO|S1.Y|S2.Y|S3.Y|S4.Y|S5.Y|VBN|VBP0|VDD_VCO|Y1|Y2|Y3|Y4|Y5|Y5_CLK_IN
+ pfet_03v3 L=1U W=78.88U AS=118.32P AD=118.32P PS=181.76U PD=181.76U
M$25
+ BUF1.NB1|BUF2.NB2|BUF3.CLK|CLK|GND_VCO|S1.Y|S2.Y|S3.Y|S4.Y|S5.Y|VBN|VBP0|VDD_VCO|Y1|Y2|Y3|Y4|Y5|Y5_CLK_IN
+ \$37
+ BUF1.NB1|BUF2.NB2|BUF3.CLK|CLK|GND_VCO|S1.Y|S2.Y|S3.Y|S4.Y|S5.Y|VBN|VBP0|VDD_VCO|Y1|Y2|Y3|Y4|Y5|Y5_CLK_IN
+ BUF1.NB1|BUF2.NB2|BUF3.CLK|CLK|GND_VCO|S1.Y|S2.Y|S3.Y|S4.Y|S5.Y|VBN|VBP0|VDD_VCO|Y1|Y2|Y3|Y4|Y5|Y5_CLK_IN
+ pfet_03v3 L=1U W=12.3U AS=18.45P AD=18.45P PS=27.6U PD=27.6U
M$30
+ BUF1.NB1|BUF2.NB2|BUF3.CLK|CLK|GND_VCO|S1.Y|S2.Y|S3.Y|S4.Y|S5.Y|VBN|VBP0|VDD_VCO|Y1|Y2|Y3|Y4|Y5|Y5_CLK_IN
+ VBP|VDD_VCO VBP|VDD_VCO
+ BUF1.NB1|BUF2.NB2|BUF3.CLK|CLK|GND_VCO|S1.Y|S2.Y|S3.Y|S4.Y|S5.Y|VBN|VBP0|VDD_VCO|Y1|Y2|Y3|Y4|Y5|Y5_CLK_IN
+ pfet_03v3 L=0.5U W=10U AS=15P AD=15P PS=23U PD=23U
M$31 VBP|VDD_VCO
+ BUF1.NB1|BUF2.NB2|BUF3.CLK|CLK|GND_VCO|S1.Y|S2.Y|S3.Y|S4.Y|S5.Y|VBN|VBP0|VDD_VCO|Y1|Y2|Y3|Y4|Y5|Y5_CLK_IN
+ BUF1.NB1|BUF2.NB2|BUF3.CLK|CLK|GND_VCO|S1.Y|S2.Y|S3.Y|S4.Y|S5.Y|VBN|VBP0|VDD_VCO|Y1|Y2|Y3|Y4|Y5|Y5_CLK_IN
+ BUF1.NB1|BUF2.NB2|BUF3.CLK|CLK|GND_VCO|S1.Y|S2.Y|S3.Y|S4.Y|S5.Y|VBN|VBP0|VDD_VCO|Y1|Y2|Y3|Y4|Y5|Y5_CLK_IN
+ pfet_03v3 L=0.28U W=25U AS=12.5P AD=12.5P PS=55U PD=55U
M$36 VBP|VDD_VCO VBP|VDD_VCO VBP|VDD_VCO
+ BUF1.NB1|BUF2.NB2|BUF3.CLK|CLK|GND_VCO|S1.Y|S2.Y|S3.Y|S4.Y|S5.Y|VBN|VBP0|VDD_VCO|Y1|Y2|Y3|Y4|Y5|Y5_CLK_IN
+ pfet_03v3 L=0.5U W=50U AS=25P AD=25P PS=105U PD=105U
M$41
+ BUF1.NB1|BUF2.NB2|BUF3.CLK|CLK|GND_VCO|S1.Y|S2.Y|S3.Y|S4.Y|S5.Y|VBN|VBP0|VDD_VCO|Y1|Y2|Y3|Y4|Y5|Y5_CLK_IN
+ BUF1.NB1|BUF2.NB2|BUF3.CLK|CLK|GND_VCO|S1.Y|S2.Y|S3.Y|S4.Y|S5.Y|VBN|VBP0|VDD_VCO|Y1|Y2|Y3|Y4|Y5|Y5_CLK_IN
+ BUF1.NB1|BUF2.NB2|BUF3.CLK|CLK|GND_VCO|S1.Y|S2.Y|S3.Y|S4.Y|S5.Y|VBN|VBP0|VDD_VCO|Y1|Y2|Y3|Y4|Y5|Y5_CLK_IN
+ BUF1.NB1|BUF2.NB2|BUF3.CLK|CLK|GND_VCO|S1.Y|S2.Y|S3.Y|S4.Y|S5.Y|VBN|VBP0|VDD_VCO|Y1|Y2|Y3|Y4|Y5|Y5_CLK_IN
+ pfet_03v3 L=0.28U W=16.25U AS=8.125P AD=8.125P PS=35.5U PD=35.5U
M$44
+ BUF1.NB1|BUF2.NB2|BUF3.CLK|CLK|GND_VCO|S1.Y|S2.Y|S3.Y|S4.Y|S5.Y|VBN|VBP0|VDD_VCO|Y1|Y2|Y3|Y4|Y5|Y5_CLK_IN
+ BUF1.NB1|BUF2.NB2|BUF3.CLK|CLK|GND_VCO|S1.Y|S2.Y|S3.Y|S4.Y|S5.Y|VBN|VBP0|VDD_VCO|Y1|Y2|Y3|Y4|Y5|Y5_CLK_IN
+ BUF1.NB1|BUF2.NB2|BUF3.CLK|CLK|GND_VCO|S1.Y|S2.Y|S3.Y|S4.Y|S5.Y|VBN|VBP0|VDD_VCO|Y1|Y2|Y3|Y4|Y5|Y5_CLK_IN
+ GND_VCO nfet_03v3 L=0.28U W=16.5U AS=8.25P AD=8.25P PS=41U PD=41U
M$50
+ BUF1.NB1|BUF2.NB2|BUF3.CLK|CLK|GND_VCO|S1.Y|S2.Y|S3.Y|S4.Y|S5.Y|VBN|VBP0|VDD_VCO|Y1|Y2|Y3|Y4|Y5|Y5_CLK_IN
+ BUF1.NB1|BUF2.NB2|BUF3.CLK|CLK|GND_VCO|S1.Y|S2.Y|S3.Y|S4.Y|S5.Y|VBN|VBP0|VDD_VCO|Y1|Y2|Y3|Y4|Y5|Y5_CLK_IN
+ BUF1.NB1|BUF2.NB2|BUF3.CLK|CLK|GND_VCO|S1.Y|S2.Y|S3.Y|S4.Y|S5.Y|VBN|VBP0|VDD_VCO|Y1|Y2|Y3|Y4|Y5|Y5_CLK_IN
+ GND_VCO nfet_03v3 L=0.5U W=20U AS=10P AD=10P PS=45U PD=45U
M$53 \$37 \$33 GND_VCO GND_VCO nfet_03v3 L=1U W=8.61U AS=12.915P AD=12.915P
+ PS=23.22U PD=23.22U
M$54
+ BUF1.NB1|BUF2.NB2|BUF3.CLK|CLK|GND_VCO|S1.Y|S2.Y|S3.Y|S4.Y|S5.Y|VBN|VBP0|VDD_VCO|Y1|Y2|Y3|Y4|Y5|Y5_CLK_IN
+ BUF1.NB1|BUF2.NB2|BUF3.CLK|CLK|GND_VCO|S1.Y|S2.Y|S3.Y|S4.Y|S5.Y|VBN|VBP0|VDD_VCO|Y1|Y2|Y3|Y4|Y5|Y5_CLK_IN
+ NOFF GND_VCO nfet_03v3 L=1U W=10U AS=15P AD=15P PS=23U PD=23U
M$55
+ BUF1.NB1|BUF2.NB2|BUF3.CLK|CLK|GND_VCO|S1.Y|S2.Y|S3.Y|S4.Y|S5.Y|VBN|VBP0|VDD_VCO|Y1|Y2|Y3|Y4|Y5|Y5_CLK_IN
+ BUF1.NB1|BUF2.NB2|BUF3.CLK|CLK|GND_VCO|S1.Y|S2.Y|S3.Y|S4.Y|S5.Y|VBN|VBP0|VDD_VCO|Y1|Y2|Y3|Y4|Y5|Y5_CLK_IN
+ GND_VCO GND_VCO nfet_03v3 L=0.5U W=4U AS=6P AD=6P PS=11U PD=11U
M$56 \$37 \$36 GND_VCO GND_VCO nfet_03v3 L=1U W=5U AS=7.5P AD=7.5P PS=16U PD=16U
M$58 \$36 \$36 GND_VCO GND_VCO nfet_03v3 L=1U W=10U AS=15P AD=15P PS=23U PD=23U
M$59 \$38 B2 GND_VCO GND_VCO nfet_03v3 L=0.28U W=1U AS=1.5P AD=1.5P PS=5U PD=5U
M$60 \$34 B1 GND_VCO GND_VCO nfet_03v3 L=0.28U W=1U AS=1.5P AD=1.5P PS=5U PD=5U
M$61 \$35 B0 GND_VCO GND_VCO nfet_03v3 L=0.28U W=1U AS=1.5P AD=1.5P PS=5U PD=5U
M$62 \$33 \$34 GND_VCO GND_VCO nfet_03v3 L=0.5U W=2U AS=3P AD=3P PS=7U PD=7U
M$63 \$33 B1 \$36 GND_VCO nfet_03v3 L=0.5U W=2U AS=3P AD=3P PS=7U PD=7U
M$64
+ BUF1.NB1|BUF2.NB2|BUF3.CLK|CLK|GND_VCO|S1.Y|S2.Y|S3.Y|S4.Y|S5.Y|VBN|VBP0|VDD_VCO|Y1|Y2|Y3|Y4|Y5|Y5_CLK_IN
+ BUF1.NB1|BUF2.NB2|BUF3.CLK|CLK|GND_VCO|S1.Y|S2.Y|S3.Y|S4.Y|S5.Y|VBN|VBP0|VDD_VCO|Y1|Y2|Y3|Y4|Y5|Y5_CLK_IN
+ GND_VCO GND_VCO nfet_03v3 L=1U W=4.4U AS=6.6P AD=6.6P PS=17.8U PD=17.8U
M$66
+ BUF1.NB1|BUF2.NB2|BUF3.CLK|CLK|GND_VCO|S1.Y|S2.Y|S3.Y|S4.Y|S5.Y|VBN|VBP0|VDD_VCO|Y1|Y2|Y3|Y4|Y5|Y5_CLK_IN
+ VCTRL NVI GND_VCO nfet_03v3 L=1U W=10U AS=15P AD=15P PS=23U PD=23U
M$69
+ BUF1.NB1|BUF2.NB2|BUF3.CLK|CLK|GND_VCO|S1.Y|S2.Y|S3.Y|S4.Y|S5.Y|VBN|VBP0|VDD_VCO|Y1|Y2|Y3|Y4|Y5|Y5_CLK_IN
+ BUF1.NB1|BUF2.NB2|BUF3.CLK|CLK|GND_VCO|S1.Y|S2.Y|S3.Y|S4.Y|S5.Y|VBN|VBP0|VDD_VCO|Y1|Y2|Y3|Y4|Y5|Y5_CLK_IN
+ \$7 GND_VCO nfet_03v3 L=1U W=2U AS=3P AD=3P PS=7U PD=7U
M$70 \$7 \$7 GND_VCO GND_VCO nfet_03v3 L=1U W=2U AS=3P AD=3P PS=7U PD=7U
M$74 VBP|VDD_VCO
+ BUF1.NB1|BUF2.NB2|BUF3.CLK|CLK|GND_VCO|S1.Y|S2.Y|S3.Y|S4.Y|S5.Y|VBN|VBP0|VDD_VCO|Y1|Y2|Y3|Y4|Y5|Y5_CLK_IN
+ GND_VCO GND_VCO nfet_03v3 L=0.5U W=4U AS=6P AD=6P PS=11U PD=11U
M$76
+ BUF1.NB1|BUF2.NB2|BUF3.CLK|CLK|GND_VCO|S1.Y|S2.Y|S3.Y|S4.Y|S5.Y|VBN|VBP0|VDD_VCO|Y1|Y2|Y3|Y4|Y5|Y5_CLK_IN
+ BUF1.NB1|BUF2.NB2|BUF3.CLK|CLK|GND_VCO|S1.Y|S2.Y|S3.Y|S4.Y|S5.Y|VBN|VBP0|VDD_VCO|Y1|Y2|Y3|Y4|Y5|Y5_CLK_IN
+ NC GND_VCO nfet_03v3 L=1U W=5.6U AS=8.4P AD=8.4P PS=14.2U PD=14.2U
R$77 GND_VCO NC GND_VCO 1960 ppolyf_u L=5.6U W=1U
R$78 GND_VCO NOFF GND_VCO 11550 ppolyf_u L=33U W=1U
R$79 GND_VCO NVI GND_VCO 11550 ppolyf_u L=33U W=1U
.ENDS vco_block
