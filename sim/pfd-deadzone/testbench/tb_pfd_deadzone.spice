* gf180-pll :: pfd-deadzone :: phase-to-charge transfer through zero phase error
*
* sim/harness fragment.  The DUT (`pfd_cp`, the tri-state PFD driving its real
* charge pump) is NOT in this file: the manifest's `dut_export` block has
* design/netlist.sh export the xschem hierarchy once per record and the harness
* `.include`s it ahead of this fragment.  This file is stimulus and measurement
* topology only, so a schematic edit this deck does not track is a netlist
* error rather than a silently divergent second copy of the design.
*
* What this measures, and why the charge domain rather than the logic domain:
* a PFD "dead zone" is only incidentally a digital-logic property.  What the
* loop actually sees is the CHARGE the pump delivers per reference cycle as a
* function of phase error, and a PFD whose UP/DN pulses are technically
* non-zero but too narrow to turn the charge-pump switches fully on still has
* a dead zone -- a flat region of Q(dphi) around zero where the loop has no
* gain.  So the DUT here is the PFD *with its real charge-pump load*, the
* measured quantity is net charge per reference cycle into the control node,
* and the acceptance criterion is that Q(dphi) stays proportional through
* dphi = 0 rather than flattening.  The UP/DN pulse widths are recorded
* alongside as the supporting logic-level evidence (and because the minimum
* UP/DN width IS the PFD reset delay that #11's retiming pulse must exceed).
*
* This is the same circuit the pre-migration `tb_pfd_deadzone.sp` describes,
* with the `.include` / `.option` / `.control` block lifted into `tb.json`
* (the harness owns those) and `dphi` promoted from a run.sh-substituted
* parameter to a declared `sweeps` axis.  ONE ngspice invocation per
* (PVT corner, dphi) point, exactly as before: replicating the five phase
* offsets as five copies of the DUT inside one deck was tried and rejected --
* five ideal control-node sources each carrying the DR-005 dump-node buffer's
* displacement current do not co-converge (`Timestep too small ... trouble
* with node vctl_p1n#branch` at the very first transient step), and buying
* convergence with a looser tolerance would have changed the numbers this
* migration has to reproduce.
*
* Expects from the harness header:
*   .lib <process corner bundle>, .temp <temp_c>
*   .param vdd_val=<supply volts>  (also vdd_nom, temp_c)
*   .param iunit, b0_code, b1_code, vctrl, period, tstart  (manifest `params`)
*   .param dphi=<FB-relative-to-REF phase offset, s>       (the `dphi` axis)

*------------------------------------------------------------------ supplies
vdd vdd 0 dc 'vdd_val'
vss vss 0 dc 0

* Reference period 40 ns (25 MHz) -- the TOP of DR-002 Decision 1's ratified
* 1-25 MHz v1 reference range, deliberately: the reset-and-recover window is
* the largest fraction of the reference period there, so 25 MHz is the
* demanding end for a dead-zone claim, and a result that holds here holds for
* every slower reference in the range.  Edges get a 200 ps rise/fall rather
* than an ideal step: a zero-rise-time stimulus would flatter every delay in
* the PFD's set path and understate the reset delay this record reports.
vref ref 0 pulse(0 'vdd_val' 'tstart' 200p 200p '0.5*period' period)
vfb  fb  0 pulse(0 'vdd_val' 'tstart+dphi' 200p 200p '0.5*period' period)

* Static trim code: b1 b0 = 1 0 -> Icp = 3 units (the nominal setting,
* mid-range of the 2-bit trim -- see design/README.md).
vb0 b0 0 dc 'vdd_val*b0_code'
vb1 b1 0 dc 'vdd_val*b1_code'

* Charge-pump bias reference.  As in sim/devchar-cp, the four bias nodes are
* driven from ideal current sources at 4x the unit-leg current (the bias
* diodes are 4x the unit geometry, so each leg still mirrors one unit):
* reference generation is a separate block, and driving it ideally here keeps
* the measured behaviour the PFD+CP's own.
iibn vdd ibn dc 'iunit'
iicn vdd icn dc 'iunit'
iibp ibp 0 dc 'iunit'
iicp icp 0 dc 'iunit'

xdut ref fb b0 b1 ibn icn ibp icp vout up dn vdd vss pfd_cp

* Control node held at vctrl through an ammeter, so i(vam) is exactly the
* charge-pump output current (positive = pump sourcing into the control node).
* vctrl = 1.65 V is the mid of DR-001 Decision 2's ~0.9-2.4 V Vctrl window;
* holding it with an ideal source isolates the pump's delivered charge from
* the loop filter's response to it (#10).
vam vout vctrl_src 0
vctrl vctrl_src 0 dc 'vctrl'
