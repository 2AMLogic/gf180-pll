* Extracted by KLayout with GF180MCU LVS runset on : 09/09/2026 01:18

.SUBCKT nor2_3v3 VSS A B Y VDD
M$1 VDD A \$8 VDD pfet_03v3 L=0.28U W=5U AS=2.5P AD=2.5P PS=11U PD=11U
M$2 \$8 B Y VDD pfet_03v3 L=0.28U W=5U AS=2.5P AD=2.5P PS=11U PD=11U
M$3 Y B VSS VSS nfet_03v3 L=0.28U W=1U AS=0.5P AD=0.5P PS=3U PD=3U
M$4 Y A VSS VSS nfet_03v3 L=0.28U W=1U AS=0.5P AD=0.5P PS=3U PD=3U
.ENDS nor2_3v3
