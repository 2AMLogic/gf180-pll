* Extracted by KLayout with GF180MCU LVS runset on : 22/09/2026 23:58

.SUBCKT pfd_cp IBP IBN VSS B0 VDD ICN ICP B1 VOUT UP REF DN FB
M$1 IBP IBP VDD VDD pfet_03v3 L=1U W=48U AS=24P AD=24P PS=97U PD=97U
M$2 ICP ICP VDD VDD pfet_03v3 L=1U W=12U AS=6P AD=6P PS=25U PD=25U
M$3 \$4 \$4 VDD VDD pfet_03v3 L=1U W=24U AS=12P AD=12P PS=49U PD=49U
M$4 \$5 \$4 VDD VDD pfet_03v3 L=1U W=24U AS=12P AD=12P PS=49U PD=49U
M$5 \$9 B0 VDD VDD pfet_03v3 L=0.3U W=1U AS=0.5P AD=0.5P PS=3U PD=3U
M$6 \$29 \$9 VDD VDD pfet_03v3 L=1U W=12U AS=6P AD=6P PS=25U PD=25U
M$7 \$10 B1 VDD VDD pfet_03v3 L=0.3U W=1U AS=0.5P AD=0.5P PS=3U PD=3U
M$8 \$30 \$10 VDD VDD pfet_03v3 L=1U W=12U AS=6P AD=6P PS=25U PD=25U
M$9 IBP \$26 \$9 VDD pfet_03v3 L=0.3U W=1U AS=0.5P AD=0.5P PS=3U PD=3U
M$10 IBP \$76 \$10 VDD pfet_03v3 L=0.3U W=1U AS=0.5P AD=0.5P PS=3U PD=3U
M$11 \$68 ICP \$29 VDD pfet_03v3 L=1U W=12U AS=6P AD=6P PS=25U PD=25U
M$12 \$68 ICP \$30 VDD pfet_03v3 L=1U W=12U AS=6P AD=6P PS=25U PD=25U
M$13 \$55 VDD VDD VDD pfet_03v3 L=0.3U W=1U AS=0.5P AD=0.5P PS=3U PD=3U
M$14 \$56 \$55 VDD VDD pfet_03v3 L=1U W=12U AS=6P AD=6P PS=25U PD=25U
M$15 IBP VSS \$55 VDD pfet_03v3 L=0.3U W=1U AS=0.5P AD=0.5P PS=3U PD=3U
M$16 \$68 ICP \$56 VDD pfet_03v3 L=1U W=12U AS=6P AD=6P PS=25U PD=25U
M$17 \$80 IBP VDD VDD pfet_03v3 L=1U W=48U AS=24P AD=24P PS=98U PD=98U
M$19 \$81 VOUT \$80 \$80 pfet_03v3 L=1U W=48U AS=24P AD=24P PS=98U PD=98U
M$20 \$5 \$5 \$80 \$80 pfet_03v3 L=1U W=48U AS=24P AD=24P PS=98U PD=98U
M$23 \$85 B1 VDD VDD pfet_03v3 L=0.3U W=1U AS=0.5P AD=0.5P PS=3U PD=3U
M$24 \$86 \$85 VDD VDD pfet_03v3 L=1U W=12U AS=6P AD=6P PS=25U PD=25U
M$25 IBP \$76 \$85 VDD pfet_03v3 L=0.3U W=1U AS=0.5P AD=0.5P PS=3U PD=3U
M$26 \$68 ICP \$86 VDD pfet_03v3 L=1U W=12U AS=6P AD=6P PS=25U PD=25U
M$27 \$68 \$137 VOUT VDD pfet_03v3 L=0.3U W=6U AS=3P AD=3P PS=13U PD=13U
M$28 \$68 UP \$5 VDD pfet_03v3 L=0.3U W=6U AS=3P AD=3P PS=13U PD=13U
M$29 VOUT UP VOUT VDD pfet_03v3 L=0.3U W=3U AS=1.5P AD=1.5P PS=7U PD=7U
M$30 \$129 REF VDD VDD pfet_03v3 L=0.3U W=1.5U AS=1.5P AD=1.5P PS=5U PD=5U
M$31 \$130 \$129 VDD VDD pfet_03v3 L=0.3U W=1.5U AS=1.5P AD=1.5P PS=5U PD=5U
M$32 \$131 \$130 VDD VDD pfet_03v3 L=0.3U W=1.5U AS=1.5P AD=1.5P PS=5U PD=5U
M$33 \$132 \$131 VDD VDD pfet_03v3 L=0.3U W=1.5U AS=1.5P AD=1.5P PS=5U PD=5U
M$34 \$133 \$132 VDD VDD pfet_03v3 L=0.3U W=1.5U AS=1.5P AD=1.5P PS=5U PD=5U
M$35 \$118 REF VDD VDD pfet_03v3 L=0.3U W=1.5U AS=1.5P AD=1.5P PS=5U PD=5U
M$36 VDD \$133 \$118 VDD pfet_03v3 L=0.3U W=1.5U AS=1.5P AD=1.5P PS=5U PD=5U
M$37 \$134 \$118 VDD VDD pfet_03v3 L=0.3U W=1.5U AS=1.5P AD=1.5P PS=5U PD=5U
M$38 \$135 \$134 VDD VDD pfet_03v3 L=0.3U W=1.5U AS=1.5P AD=1.5P PS=5U PD=5U
M$39 UP \$135 VDD VDD pfet_03v3 L=0.3U W=1.5U AS=1.5P AD=1.5P PS=5U PD=5U
M$40 VDD \$139 UP VDD pfet_03v3 L=0.3U W=1.5U AS=1.5P AD=1.5P PS=5U PD=5U
M$41 \$139 \$140 VDD VDD pfet_03v3 L=0.3U W=1.5U AS=1.5P AD=1.5P PS=5U PD=5U
M$42 VDD UP \$139 VDD pfet_03v3 L=0.3U W=1.5U AS=1.5P AD=1.5P PS=5U PD=5U
M$43 \$122 UP VDD VDD pfet_03v3 L=0.3U W=1.5U AS=1.5P AD=1.5P PS=5U PD=5U
M$44 VDD DN \$122 VDD pfet_03v3 L=0.3U W=1.5U AS=1.5P AD=1.5P PS=5U PD=5U
M$45 \$142 DN VDD VDD pfet_03v3 L=0.3U W=1.5U AS=1.5P AD=1.5P PS=5U PD=5U
M$46 VDD \$140 \$142 VDD pfet_03v3 L=0.3U W=1.5U AS=1.5P AD=1.5P PS=5U PD=5U
M$47 DN \$142 VDD VDD pfet_03v3 L=0.3U W=1.5U AS=1.5P AD=1.5P PS=5U PD=5U
M$48 VDD \$143 DN VDD pfet_03v3 L=0.3U W=1.5U AS=1.5P AD=1.5P PS=5U PD=5U
M$49 VDD \$144 \$143 VDD pfet_03v3 L=0.3U W=1.5U AS=1.5P AD=1.5P PS=5U PD=5U
M$50 VDD \$145 \$144 VDD pfet_03v3 L=0.3U W=1.5U AS=1.5P AD=1.5P PS=5U PD=5U
M$51 \$145 \$146 VDD VDD pfet_03v3 L=0.3U W=1.5U AS=1.5P AD=1.5P PS=5U PD=5U
M$52 VDD FB \$145 VDD pfet_03v3 L=0.3U W=1.5U AS=1.5P AD=1.5P PS=5U PD=5U
M$53 VDD \$148 \$146 VDD pfet_03v3 L=0.3U W=1.5U AS=1.5P AD=1.5P PS=5U PD=5U
M$54 VDD \$149 \$148 VDD pfet_03v3 L=0.3U W=1.5U AS=1.5P AD=1.5P PS=5U PD=5U
M$55 VDD \$150 \$149 VDD pfet_03v3 L=0.3U W=1.5U AS=1.5P AD=1.5P PS=5U PD=5U
M$56 VDD \$151 \$150 VDD pfet_03v3 L=0.3U W=1.5U AS=1.5P AD=1.5P PS=5U PD=5U
M$57 VDD FB \$151 VDD pfet_03v3 L=0.3U W=1.5U AS=1.5P AD=1.5P PS=5U PD=5U
M$58 VDD DN \$136 VDD pfet_03v3 L=0.3U W=1.5U AS=0.75P AD=0.75P PS=4U PD=4U
M$59 VDD UP \$137 VDD pfet_03v3 L=0.3U W=1.5U AS=0.75P AD=0.75P PS=4U PD=4U
M$60 VDD B0 \$26 VDD pfet_03v3 L=0.3U W=1.5U AS=0.75P AD=0.75P PS=4U PD=4U
M$61 VDD B1 \$76 VDD pfet_03v3 L=0.3U W=1.5U AS=0.75P AD=0.75P PS=4U PD=4U
M$62 \$251 \$122 VDD VDD pfet_03v3 L=0.3U W=1.5U AS=1.5P AD=1.5P PS=5U PD=5U
M$63 \$252 \$251 VDD VDD pfet_03v3 L=0.3U W=1.5U AS=1.5P AD=1.5P PS=5U PD=5U
M$64 \$253 \$252 VDD VDD pfet_03v3 L=0.3U W=1.5U AS=1.5P AD=1.5P PS=5U PD=5U
M$65 \$254 \$253 VDD VDD pfet_03v3 L=0.3U W=1.5U AS=1.5P AD=1.5P PS=5U PD=5U
M$66 \$255 \$254 VDD VDD pfet_03v3 L=0.3U W=1.5U AS=1.5P AD=1.5P PS=5U PD=5U
M$67 \$256 \$255 VDD VDD pfet_03v3 L=0.3U W=1.5U AS=1.5P AD=1.5P PS=5U PD=5U
M$68 \$257 \$256 VDD VDD pfet_03v3 L=0.3U W=1.5U AS=1.5P AD=1.5P PS=5U PD=5U
M$69 \$258 \$257 VDD VDD pfet_03v3 L=0.3U W=1.5U AS=1.5P AD=1.5P PS=5U PD=5U
M$70 \$259 \$258 VDD VDD pfet_03v3 L=0.3U W=1.5U AS=1.5P AD=1.5P PS=5U PD=5U
M$71 \$260 \$259 VDD VDD pfet_03v3 L=0.3U W=1.5U AS=1.5P AD=1.5P PS=5U PD=5U
M$72 \$261 \$260 VDD VDD pfet_03v3 L=0.3U W=1.5U AS=1.5P AD=1.5P PS=5U PD=5U
M$73 \$262 \$261 VDD VDD pfet_03v3 L=0.3U W=1.5U AS=1.5P AD=1.5P PS=5U PD=5U
M$74 \$263 \$262 VDD VDD pfet_03v3 L=0.3U W=1.5U AS=1.5P AD=1.5P PS=5U PD=5U
M$75 \$264 \$263 VDD VDD pfet_03v3 L=0.3U W=1.5U AS=1.5P AD=1.5P PS=5U PD=5U
M$76 \$265 \$264 VDD VDD pfet_03v3 L=0.3U W=1.5U AS=1.5P AD=1.5P PS=5U PD=5U
M$77 \$266 \$265 VDD VDD pfet_03v3 L=0.3U W=1.5U AS=1.5P AD=1.5P PS=5U PD=5U
M$78 \$267 \$266 VDD VDD pfet_03v3 L=0.3U W=1.5U AS=1.5P AD=1.5P PS=5U PD=5U
M$79 \$268 \$267 VDD VDD pfet_03v3 L=0.3U W=1.5U AS=1.5P AD=1.5P PS=5U PD=5U
M$80 \$269 \$268 VDD VDD pfet_03v3 L=0.3U W=1.5U AS=1.5P AD=1.5P PS=5U PD=5U
M$81 \$270 \$269 VDD VDD pfet_03v3 L=0.3U W=1.5U AS=1.5P AD=1.5P PS=5U PD=5U
M$82 \$271 \$270 VDD VDD pfet_03v3 L=0.3U W=1.5U AS=1.5P AD=1.5P PS=5U PD=5U
M$83 \$272 \$271 VDD VDD pfet_03v3 L=0.3U W=1.5U AS=1.5P AD=1.5P PS=5U PD=5U
M$84 \$273 \$272 VDD VDD pfet_03v3 L=0.3U W=1.5U AS=1.5P AD=1.5P PS=5U PD=5U
M$85 \$274 \$273 VDD VDD pfet_03v3 L=0.3U W=1.5U AS=1.5P AD=1.5P PS=5U PD=5U
M$86 \$275 \$274 VDD VDD pfet_03v3 L=0.3U W=1.5U AS=1.5P AD=1.5P PS=5U PD=5U
M$87 \$140 \$275 VDD VDD pfet_03v3 L=0.3U W=1.5U AS=1.5P AD=1.5P PS=5U PD=5U
M$88 \$3 IBN VSS VSS nfet_03v3 L=1U W=16U AS=8P AD=8P PS=33U PD=33U
M$89 \$4 VOUT \$3 VSS nfet_03v3 L=1U W=16U AS=8P AD=8P PS=33U PD=33U
M$90 \$5 \$5 \$3 VSS nfet_03v3 L=1U W=16U AS=8P AD=8P PS=33U PD=33U
M$91 IBN IBN VSS VSS nfet_03v3 L=1U W=16U AS=8P AD=8P PS=33U PD=33U
M$92 ICN ICN VSS VSS nfet_03v3 L=1U W=4U AS=2P AD=2P PS=9U PD=9U
M$93 \$27 \$26 VSS VSS nfet_03v3 L=0.3U W=1U AS=0.5P AD=0.5P PS=3U PD=3U
M$94 \$35 \$27 VSS VSS nfet_03v3 L=1U W=4U AS=2P AD=2P PS=9U PD=9U
M$95 \$28 \$76 VSS VSS nfet_03v3 L=0.3U W=1U AS=0.5P AD=0.5P PS=3U PD=3U
M$96 \$36 \$28 VSS VSS nfet_03v3 L=1U W=4U AS=2P AD=2P PS=9U PD=9U
M$97 IBN B0 \$27 VSS nfet_03v3 L=0.3U W=1U AS=0.5P AD=0.5P PS=3U PD=3U
M$98 IBN B1 \$28 VSS nfet_03v3 L=0.3U W=1U AS=0.5P AD=0.5P PS=3U PD=3U
M$99 \$66 ICN \$35 VSS nfet_03v3 L=1U W=4U AS=2P AD=2P PS=9U PD=9U
M$100 \$66 ICN \$36 VSS nfet_03v3 L=1U W=4U AS=2P AD=2P PS=9U PD=9U
M$101 \$53 VSS VSS VSS nfet_03v3 L=0.3U W=1U AS=0.5P AD=0.5P PS=3U PD=3U
M$102 IBN VDD \$53 VSS nfet_03v3 L=0.3U W=1U AS=0.5P AD=0.5P PS=3U PD=3U
M$103 \$54 \$53 VSS VSS nfet_03v3 L=1U W=4U AS=2P AD=2P PS=9U PD=9U
M$104 \$66 ICN \$54 VSS nfet_03v3 L=1U W=4U AS=2P AD=2P PS=9U PD=9U
M$105 \$78 \$76 VSS VSS nfet_03v3 L=0.3U W=1U AS=0.5P AD=0.5P PS=3U PD=3U
M$106 \$79 \$78 VSS VSS nfet_03v3 L=1U W=4U AS=2P AD=2P PS=9U PD=9U
M$107 \$81 \$81 VSS VSS nfet_03v3 L=1U W=16U AS=8P AD=8P PS=33U PD=33U
M$108 \$5 \$81 VSS VSS nfet_03v3 L=1U W=16U AS=8P AD=8P PS=33U PD=33U
M$109 IBN B1 \$78 VSS nfet_03v3 L=0.3U W=1U AS=0.5P AD=0.5P PS=3U PD=3U
M$110 \$66 ICN \$79 VSS nfet_03v3 L=1U W=4U AS=2P AD=2P PS=9U PD=9U
M$111 \$119 REF \$118 VSS nfet_03v3 L=0.3U W=1U AS=1P AD=1P PS=4U PD=4U
M$112 VSS \$133 \$119 VSS nfet_03v3 L=0.3U W=1U AS=1P AD=1P PS=4U PD=4U
M$113 \$120 \$135 UP VSS nfet_03v3 L=0.3U W=1U AS=1P AD=1P PS=4U PD=4U
M$114 VSS \$139 \$120 VSS nfet_03v3 L=0.3U W=1U AS=1P AD=1P PS=4U PD=4U
M$115 \$121 \$140 \$139 VSS nfet_03v3 L=0.3U W=1U AS=1P AD=1P PS=4U PD=4U
M$116 VSS UP \$121 VSS nfet_03v3 L=0.3U W=1U AS=1P AD=1P PS=4U PD=4U
M$117 \$123 UP \$122 VSS nfet_03v3 L=0.3U W=1U AS=1P AD=1P PS=4U PD=4U
M$118 VSS DN \$123 VSS nfet_03v3 L=0.3U W=1U AS=1P AD=1P PS=4U PD=4U
M$119 \$124 DN VSS VSS nfet_03v3 L=0.3U W=1U AS=1P AD=1P PS=4U PD=4U
M$120 \$142 \$140 \$124 VSS nfet_03v3 L=0.3U W=1U AS=1P AD=1P PS=4U PD=4U
M$121 \$125 \$142 VSS VSS nfet_03v3 L=0.3U W=1U AS=1P AD=1P PS=4U PD=4U
M$122 DN \$143 \$125 VSS nfet_03v3 L=0.3U W=1U AS=1P AD=1P PS=4U PD=4U
M$123 \$126 \$146 VSS VSS nfet_03v3 L=0.3U W=1U AS=1P AD=1P PS=4U PD=4U
M$124 \$145 FB \$126 VSS nfet_03v3 L=0.3U W=1U AS=1P AD=1P PS=4U PD=4U
M$125 \$129 REF VSS VSS nfet_03v3 L=0.3U W=0.5U AS=0.5P AD=0.5P PS=3U PD=3U
M$126 \$130 \$129 VSS VSS nfet_03v3 L=0.3U W=0.5U AS=0.5P AD=0.5P PS=3U PD=3U
M$127 \$131 \$130 VSS VSS nfet_03v3 L=0.3U W=0.5U AS=0.5P AD=0.5P PS=3U PD=3U
M$128 \$132 \$131 VSS VSS nfet_03v3 L=0.3U W=0.5U AS=0.5P AD=0.5P PS=3U PD=3U
M$129 \$133 \$132 VSS VSS nfet_03v3 L=0.3U W=0.5U AS=0.5P AD=0.5P PS=3U PD=3U
M$130 \$134 \$118 VSS VSS nfet_03v3 L=0.3U W=0.5U AS=0.5P AD=0.5P PS=3U PD=3U
M$131 \$135 \$134 VSS VSS nfet_03v3 L=0.3U W=0.5U AS=0.5P AD=0.5P PS=3U PD=3U
M$132 VSS \$144 \$143 VSS nfet_03v3 L=0.3U W=0.5U AS=0.5P AD=0.5P PS=3U PD=3U
M$133 VSS \$145 \$144 VSS nfet_03v3 L=0.3U W=0.5U AS=0.5P AD=0.5P PS=3U PD=3U
M$134 VSS \$148 \$146 VSS nfet_03v3 L=0.3U W=0.5U AS=0.5P AD=0.5P PS=3U PD=3U
M$135 VSS \$149 \$148 VSS nfet_03v3 L=0.3U W=0.5U AS=0.5P AD=0.5P PS=3U PD=3U
M$136 VSS \$150 \$149 VSS nfet_03v3 L=0.3U W=0.5U AS=0.5P AD=0.5P PS=3U PD=3U
M$137 VSS \$151 \$150 VSS nfet_03v3 L=0.3U W=0.5U AS=0.5P AD=0.5P PS=3U PD=3U
M$138 VSS FB \$151 VSS nfet_03v3 L=0.3U W=0.5U AS=0.5P AD=0.5P PS=3U PD=3U
M$139 \$136 DN VSS VSS nfet_03v3 L=0.3U W=0.5U AS=0.25P AD=0.25P PS=2U PD=2U
M$140 VOUT DN \$66 VSS nfet_03v3 L=0.3U W=6U AS=3P AD=3P PS=13U PD=13U
M$141 \$5 \$136 \$66 VSS nfet_03v3 L=0.3U W=6U AS=3P AD=3P PS=13U PD=13U
M$142 VOUT \$136 VOUT VSS nfet_03v3 L=0.3U W=3U AS=1.5P AD=1.5P PS=7U PD=7U
M$143 \$137 UP VSS VSS nfet_03v3 L=0.3U W=0.5U AS=0.25P AD=0.25P PS=2U PD=2U
M$144 \$26 B0 VSS VSS nfet_03v3 L=0.3U W=0.5U AS=0.25P AD=0.25P PS=2U PD=2U
M$145 \$76 B1 VSS VSS nfet_03v3 L=0.3U W=0.5U AS=0.25P AD=0.25P PS=2U PD=2U
M$146 \$251 \$122 VSS VSS nfet_03v3 L=0.3U W=0.5U AS=0.5P AD=0.5P PS=3U PD=3U
M$147 \$252 \$251 VSS VSS nfet_03v3 L=0.3U W=0.5U AS=0.5P AD=0.5P PS=3U PD=3U
M$148 \$253 \$252 VSS VSS nfet_03v3 L=0.3U W=0.5U AS=0.5P AD=0.5P PS=3U PD=3U
M$149 \$254 \$253 VSS VSS nfet_03v3 L=0.3U W=0.5U AS=0.5P AD=0.5P PS=3U PD=3U
M$150 \$255 \$254 VSS VSS nfet_03v3 L=0.3U W=0.5U AS=0.5P AD=0.5P PS=3U PD=3U
M$151 \$256 \$255 VSS VSS nfet_03v3 L=0.3U W=0.5U AS=0.5P AD=0.5P PS=3U PD=3U
M$152 \$257 \$256 VSS VSS nfet_03v3 L=0.3U W=0.5U AS=0.5P AD=0.5P PS=3U PD=3U
M$153 \$258 \$257 VSS VSS nfet_03v3 L=0.3U W=0.5U AS=0.5P AD=0.5P PS=3U PD=3U
M$154 \$259 \$258 VSS VSS nfet_03v3 L=0.3U W=0.5U AS=0.5P AD=0.5P PS=3U PD=3U
M$155 \$260 \$259 VSS VSS nfet_03v3 L=0.3U W=0.5U AS=0.5P AD=0.5P PS=3U PD=3U
M$156 \$261 \$260 VSS VSS nfet_03v3 L=0.3U W=0.5U AS=0.5P AD=0.5P PS=3U PD=3U
M$157 \$262 \$261 VSS VSS nfet_03v3 L=0.3U W=0.5U AS=0.5P AD=0.5P PS=3U PD=3U
M$158 \$263 \$262 VSS VSS nfet_03v3 L=0.3U W=0.5U AS=0.5P AD=0.5P PS=3U PD=3U
M$159 \$264 \$263 VSS VSS nfet_03v3 L=0.3U W=0.5U AS=0.5P AD=0.5P PS=3U PD=3U
M$160 \$265 \$264 VSS VSS nfet_03v3 L=0.3U W=0.5U AS=0.5P AD=0.5P PS=3U PD=3U
M$161 \$266 \$265 VSS VSS nfet_03v3 L=0.3U W=0.5U AS=0.5P AD=0.5P PS=3U PD=3U
M$162 \$267 \$266 VSS VSS nfet_03v3 L=0.3U W=0.5U AS=0.5P AD=0.5P PS=3U PD=3U
M$163 \$268 \$267 VSS VSS nfet_03v3 L=0.3U W=0.5U AS=0.5P AD=0.5P PS=3U PD=3U
M$164 \$269 \$268 VSS VSS nfet_03v3 L=0.3U W=0.5U AS=0.5P AD=0.5P PS=3U PD=3U
M$165 \$270 \$269 VSS VSS nfet_03v3 L=0.3U W=0.5U AS=0.5P AD=0.5P PS=3U PD=3U
M$166 \$271 \$270 VSS VSS nfet_03v3 L=0.3U W=0.5U AS=0.5P AD=0.5P PS=3U PD=3U
M$167 \$272 \$271 VSS VSS nfet_03v3 L=0.3U W=0.5U AS=0.5P AD=0.5P PS=3U PD=3U
M$168 \$273 \$272 VSS VSS nfet_03v3 L=0.3U W=0.5U AS=0.5P AD=0.5P PS=3U PD=3U
M$169 \$274 \$273 VSS VSS nfet_03v3 L=0.3U W=0.5U AS=0.5P AD=0.5P PS=3U PD=3U
M$170 \$275 \$274 VSS VSS nfet_03v3 L=0.3U W=0.5U AS=0.5P AD=0.5P PS=3U PD=3U
M$171 \$140 \$275 VSS VSS nfet_03v3 L=0.3U W=0.5U AS=0.5P AD=0.5P PS=3U PD=3U
.ENDS pfd_cp
