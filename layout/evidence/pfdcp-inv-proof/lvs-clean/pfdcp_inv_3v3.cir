* Extracted by KLayout with GF180MCU LVS runset on : 08/09/2026 20:56

.SUBCKT pfdcp_inv_3v3 VSS VDD
M$1 VDD \$1 \$3 VDD pfet_03v3 L=0.3U W=1.5U AS=0.75P AD=0.75P PS=4U PD=4U
M$2 \$3 \$1 VSS VSS nfet_03v3 L=0.3U W=0.5U AS=0.25P AD=0.25P PS=2U PD=2U
.ENDS pfdcp_inv_3v3
