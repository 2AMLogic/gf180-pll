* ASSEMBLED by sim/lib/assemble_closed_loop.sh -- do not edit.
* DUT: design/netlist/pll_top.spice (export of design/pll_top.sch, #52)
* Stimulus: sim/supply-sensitivity/testbench/tb_supply_dyn.sp
* gf180-pll :: pll_top -- generated by design/netlist.sh from pll_top.sch
* xschem XSCHEM V3.4.7; do not edit by hand.
** sch_path: design/pll_top.sch
.subckt pll_top REF B0 B1 B2 CPB0 CPB1 P0 P1 P2 P3 P4 P5 SEL0 SEL1 SEL2 SEL3 SEL4 SEL5 IBN ICN IBP ICP CLK DIVOUT FB LOCK VCTRL
+ VDD VDD_VCO GND_VCO VDD_DIV VSS
*.ipin REF
*.ipin B0
*.ipin B1
*.ipin B2
*.ipin CPB0
*.ipin CPB1
*.ipin P0
*.ipin P1
*.ipin P2
*.ipin P3
*.ipin P4
*.ipin P5
*.ipin SEL0
*.ipin SEL1
*.ipin SEL2
*.ipin SEL3
*.ipin SEL4
*.ipin SEL5
*.ipin IBN
*.ipin ICN
*.ipin IBP
*.ipin ICP
*.opin CLK
*.opin DIVOUT
*.opin FB
*.opin LOCK
*.iopin VCTRL
*.iopin VDD
*.iopin VDD_VCO
*.iopin GND_VCO
*.iopin VDD_DIV
*.iopin VSS
XPFD REF FB CPB0 CPB1 IBN ICN IBP ICP VCTRL UP DN VDD VSS pfd_cp
XLF VCTRL VSS loop_filter
XVCO VCTRL B0 B1 B2 CLK VDD_VCO GND_VCO vco
XDIV CLK P0 P1 P2 P3 P4 P5 SEL0 SEL1 SEL2 SEL3 SEL4 SEL5 DIVOUT FB VDD_DIV VSS divider_chain
XLD UP DN LOCK VWIN VDD VSS lock_detector
.ends

* expanding   symbol:  pfd_cp.sym # of pins=13
** sym_path: design/pfd_cp.sym
** sch_path: design/pfd_cp.sch
.subckt pfd_cp REF FB B0 B1 IBN ICN IBP ICP VOUT UP DN VDD VSS
*.ipin REF
*.ipin FB
*.ipin B0
*.ipin B1
*.iopin IBN
*.iopin ICN
*.iopin IBP
*.iopin ICP
*.iopin VOUT
*.opin UP
*.opin DN
*.iopin VDD
*.iopin VSS
xpfd REF FB UP DN VDD VSS pfd
xcp UP DN B0 B1 IBN ICN IBP ICP VOUT VDD VSS cp
.ends

* expanding   symbol:  loop_filter.sym # of pins=2
** sym_path: design/loop_filter.sym
** sch_path: design/loop_filter.sch
.subckt loop_filter VCTRL VSS
*.iopin VCTRL
*.iopin VSS
XRF1 NR1 VCTRL VSS ppolyf_u r_width=2u r_length=107u m=1
XRF2 NR2 NR1 VSS ppolyf_u r_width=2u r_length=107u m=1
XRF3 NR3 NR2 VSS ppolyf_u r_width=2u r_length=107u m=1
XRF4 NZ NR3 VSS ppolyf_u r_width=2u r_length=107u m=1
XCF1 NZ VSS cap_nmos_03v3_b c_width=87u c_length=87u m=1
XCF2 NZ VSS cap_nmos_03v3_b c_width=87u c_length=87u m=1
XCF3 NZ VSS cap_nmos_03v3_b c_width=87u c_length=87u m=1
XCF4 NZ VSS cap_nmos_03v3_b c_width=87u c_length=87u m=1
XCF5 VCTRL VSS cap_mim_2f0_m2m3_noshield c_width=31.4u c_length=31.4u m=1
.ends

* expanding   symbol:  vco.sym # of pins=7
** sym_path: design/vco.sym
** sch_path: design/vco.sch
.subckt vco VCTRL B0 B1 B2 CLK VDD_VCO GND_VCO
*.ipin VCTRL
*.ipin B0
*.ipin B1
*.ipin B2
*.opin CLK
*.iopin VDD_VCO
*.iopin GND_VCO
XBIAS VCTRL B0 B1 B2 VBP VBN VDD_VCO GND_VCO vco_bias
XS1 Y5 Y1 VDD_VCO GND_VCO VBP VBN vco_stage
XS2 Y1 Y2 VDD_VCO GND_VCO VBP VBN vco_stage
XS3 Y2 Y3 VDD_VCO GND_VCO VBP VBN vco_stage
XS4 Y3 Y4 VDD_VCO GND_VCO VBP VBN vco_stage
XS5 Y4 Y5 VDD_VCO GND_VCO VBP VBN vco_stage
XMBP1 NB1 Y5 VDD_VCO VDD_VCO pfet_03v3 L=0.28u W=1.25u nf=1 ad='int((nf+1)/2) * W/nf * 0.18u' as='int((nf+2)/2) * W/nf * 0.18u' pd='2*int((nf+1)/2) * (W/nf + 0.18u)'
+ ps='2*int((nf+2)/2) * (W/nf + 0.18u)' nrd='0.18u / W' nrs='0.18u / W' sa=0 sb=0 sd=0 m=1
XMBN1 NB1 Y5 GND_VCO GND_VCO nfet_03v3 L=0.28u W=0.5u nf=1 ad='int((nf+1)/2) * W/nf * 0.18u' as='int((nf+2)/2) * W/nf * 0.18u' pd='2*int((nf+1)/2) * (W/nf + 0.18u)'
+ ps='2*int((nf+2)/2) * (W/nf + 0.18u)' nrd='0.18u / W' nrs='0.18u / W' sa=0 sb=0 sd=0 m=1
XMBP2 NB2 NB1 VDD_VCO VDD_VCO pfet_03v3 L=0.28u W=3.75u nf=1 ad='int((nf+1)/2) * W/nf * 0.18u' as='int((nf+2)/2) * W/nf * 0.18u' pd='2*int((nf+1)/2) * (W/nf + 0.18u)'
+ ps='2*int((nf+2)/2) * (W/nf + 0.18u)' nrd='0.18u / W' nrs='0.18u / W' sa=0 sb=0 sd=0 m=1
XMBN2 NB2 NB1 GND_VCO GND_VCO nfet_03v3 L=0.28u W=1.5u nf=1 ad='int((nf+1)/2) * W/nf * 0.18u' as='int((nf+2)/2) * W/nf * 0.18u' pd='2*int((nf+1)/2) * (W/nf + 0.18u)'
+ ps='2*int((nf+2)/2) * (W/nf + 0.18u)' nrd='0.18u / W' nrs='0.18u / W' sa=0 sb=0 sd=0 m=1
XMBP3 CLK NB2 VDD_VCO VDD_VCO pfet_03v3 L=0.28u W=11.25u nf=1 ad='int((nf+1)/2) * W/nf * 0.18u' as='int((nf+2)/2) * W/nf * 0.18u' pd='2*int((nf+1)/2) * (W/nf + 0.18u)'
+ ps='2*int((nf+2)/2) * (W/nf + 0.18u)' nrd='0.18u / W' nrs='0.18u / W' sa=0 sb=0 sd=0 m=1
XMBN3 CLK NB2 GND_VCO GND_VCO nfet_03v3 L=0.28u W=4.5u nf=1 ad='int((nf+1)/2) * W/nf * 0.18u' as='int((nf+2)/2) * W/nf * 0.18u' pd='2*int((nf+1)/2) * (W/nf + 0.18u)'
+ ps='2*int((nf+2)/2) * (W/nf + 0.18u)' nrd='0.18u / W' nrs='0.18u / W' sa=0 sb=0 sd=0 m=1
XCDEC1 VDD_VCO GND_VCO cap_nmos_03v3 c_width=50u c_length=50u m=1
XCDEC2 VDD_VCO GND_VCO cap_nmos_03v3 c_width=50u c_length=50u m=1
.ends

* expanding   symbol:  divider_chain.sym # of pins=17
** sym_path: design/divider_chain.sym
** sch_path: design/divider_chain.sch
.subckt divider_chain VCO P0 P1 P2 P3 P4 P5 SEL0 SEL1 SEL2 SEL3 SEL4 SEL5 DIVOUT FB VDD_DIV VSS
*.ipin VCO
*.ipin P0
*.ipin P1
*.ipin P2
*.ipin P3
*.ipin P4
*.ipin P5
*.ipin SEL0
*.ipin SEL1
*.ipin SEL2
*.ipin SEL3
*.ipin SEL4
*.ipin SEL5
*.opin DIVOUT
*.opin FB
*.iopin VDD_DIV
*.iopin VSS
XD0 VCO MI0 P0 CK1 MO0 VDD_DIV VSS div23_cell
XD1 CK1 MI1 P1 CK2 MO1 VDD_DIV VSS div23_cell
XD2 CK2 MI2 P2 CK3 MO2 VDD_DIV VSS div23_cell
XD3 CK3 MI3 P3 CK4 MO3 VDD_DIV VSS div23_cell
XD4 CK4 MI4 P4 CK5 MO4 VDD_DIV VSS div23_cell
XD5 CK5 SEL5 P5 CK6 MO5 VDD_DIV VSS div23_cell
XNR0 MO1 SEL0 NMI0 VDD_DIV VSS nor2_3v3
XIV0 NMI0 MI0 VDD_DIV VSS inv_3v3
XNR1 MO2 SEL1 NMI1 VDD_DIV VSS nor2_3v3
XIV1 NMI1 MI1 VDD_DIV VSS inv_3v3
XNR2 MO3 SEL2 NMI2 VDD_DIV VSS nor2_3v3
XIV2 NMI2 MI2 VDD_DIV VSS inv_3v3
XNR3 MO4 SEL3 NMI3 VDD_DIV VSS nor2_3v3
XIV3 NMI3 MI3 VDD_DIV VSS inv_3v3
XNR4 MO5 SEL4 NMI4 VDD_DIV VSS nor2_3v3
XIV4 NMI4 MI4 VDD_DIV VSS inv_3v3
XM0 CK1 SEL0 T0 VDD_DIV VSS nand2_3v3
XM1 CK2 SEL1 T1 VDD_DIV VSS nand2_3v3
XM2 CK3 SEL2 T2 VDD_DIV VSS nand2_3v3
XM3 CK4 SEL3 T3 VDD_DIV VSS nand2_3v3
XM4 CK5 SEL4 T4 VDD_DIV VSS nand2_3v3
XM5 CK6 SEL5 T5 VDD_DIV VSS nand2_3v3
XMA T0 T1 T2 MA VDD_DIV VSS nand3_3v3
XMB T3 T4 T5 MB VDD_DIV VSS nand3_3v3
XMNO MA MB DIVOUTB VDD_DIV VSS nor2_3v3
XIDO DIVOUTB DIVOUT VDD_DIV VSS inv2x_3v3
XFRT DIVOUT VCO FB FBB VDD_DIV VSS dff_tg_3v3
.ends

* expanding   symbol:  lock_detector.sym # of pins=6
** sym_path: design/lock_detector.sym
** sch_path: design/lock_detector.sch
.subckt lock_detector UP DN LOCK VWIN VDD VSS
*.ipin UP
*.ipin DN
*.opin LOCK
*.opin VWIN
*.iopin VDD
*.iopin VSS
XERR UP DN ERR VDD VSS xor2_3v3
XDLY ERR ERRD VDD VSS delaywin_3v3
XNW ERR ERRD WIDEB VDD VSS nand2_3v3
XIW WIDEB WIDE VDD VSS inv_3v3
XMDNW VWIN WIDE VSS VSS nfet_03v3 L=0.5u W=2u nf=1 ad='int((nf+1)/2) * W/nf * 0.18u' as='int((nf+2)/2) * W/nf * 0.18u' pd='2*int((nf+1)/2) * (W/nf + 0.18u)'
+ ps='2*int((nf+2)/2) * (W/nf + 0.18u)' nrd='0.18u / W' nrs='0.18u / W' sa=0 sb=0 sd=0 m=1
XMUPW VWIN VSS VDD VDD pfet_03v3 L=20u W=0.22u nf=1 ad='int((nf+1)/2) * W/nf * 0.18u' as='int((nf+2)/2) * W/nf * 0.18u' pd='2*int((nf+1)/2) * (W/nf + 0.18u)'
+ ps='2*int((nf+2)/2) * (W/nf + 0.18u)' nrd='0.18u / W' nrs='0.18u / W' sa=0 sb=0 sd=0 m=1
XMCW VSS VWIN VSS VSS nfet_03v3 L=6u W=30u nf=1 ad='int((nf+1)/2) * W/nf * 0.18u' as='int((nf+2)/2) * W/nf * 0.18u' pd='2*int((nf+1)/2) * (W/nf + 0.18u)'
+ ps='2*int((nf+2)/2) * (W/nf + 0.18u)' nrd='0.18u / W' nrs='0.18u / W' sa=0 sb=0 sd=0 m=1
XSCH VWIN LOCKB VDD VSS schmitt_3v3
XILK LOCKB LOCK VDD VSS inv_3v3
.ends

* expanding   symbol:  pfd.sym # of pins=6
** sym_path: design/pfd.sym
** sch_path: design/pfd.sch
.subckt pfd REF FB UP DN VDD VSS
*.ipin REF
*.ipin FB
*.opin UP
*.opin DN
*.iopin VDD
*.iopin VSS
xed_ref REF PR VDD VSS edgedet
xed_fb FB PF VDD VSS edgedet
xinv_sr PR SBR VDD VSS pfdcp_inv_3v3
xinv_sf PF SBF VDD VSS pfdcp_inv_3v3
xlat_ref SBR RB UP UPB VDD VSS srlatch
xlat_fb SBF RB DN DNB VDD VSS srlatch
xnand_rst UP DN NRST VDD VSS pfdcp_nand2_3v3
xinv_r0 NRST RST_RAW VDD VSS pfdcp_inv_3v3
xd1 RST_RAW RD1 VDD VSS pfdcp_inv_3v3
xd2 RD1 RD2 VDD VSS pfdcp_inv_3v3
xd3 RD2 RD3 VDD VSS pfdcp_inv_3v3
xd4 RD3 RD4 VDD VSS pfdcp_inv_3v3
xd5 RD4 RD5 VDD VSS pfdcp_inv_3v3
xd6 RD5 RD6 VDD VSS pfdcp_inv_3v3
xd7 RD6 RD7 VDD VSS pfdcp_inv_3v3
xd8 RD7 RD8 VDD VSS pfdcp_inv_3v3
xd9 RD8 RD9 VDD VSS pfdcp_inv_3v3
xd10 RD9 RD10 VDD VSS pfdcp_inv_3v3
xd11 RD10 RD11 VDD VSS pfdcp_inv_3v3
xd12 RD11 RD12 VDD VSS pfdcp_inv_3v3
xd13 RD12 RD13 VDD VSS pfdcp_inv_3v3
xd14 RD13 RD14 VDD VSS pfdcp_inv_3v3
xd15 RD14 RD15 VDD VSS pfdcp_inv_3v3
xd16 RD15 RD16 VDD VSS pfdcp_inv_3v3
xd17 RD16 RD17 VDD VSS pfdcp_inv_3v3
xd18 RD17 RD18 VDD VSS pfdcp_inv_3v3
xd19 RD18 RD19 VDD VSS pfdcp_inv_3v3
xd20 RD19 RD20 VDD VSS pfdcp_inv_3v3
xd21 RD20 RD21 VDD VSS pfdcp_inv_3v3
xd22 RD21 RD22 VDD VSS pfdcp_inv_3v3
xd23 RD22 RD23 VDD VSS pfdcp_inv_3v3
xd24 RD23 RST_DLY VDD VSS pfdcp_inv_3v3
xinv_rb RST_DLY RB VDD VSS pfdcp_inv_3v3
.ends

* expanding   symbol:  cp.sym # of pins=11
** sym_path: design/cp.sym
** sch_path: design/cp.sch
.subckt cp UP DN B0 B1 IBN ICN IBP ICP VOUT VDD VSS
*.ipin UP
*.ipin DN
*.ipin B0
*.ipin B1
*.iopin IBN
*.iopin ICN
*.iopin IBP
*.iopin ICP
*.iopin VOUT
*.iopin VDD
*.iopin VSS
XMBN IBN IBN VSS VSS nfet_03v3 L=1u W=16u nf=1 ad='int((nf+1)/2) * W/nf * 0.18u' as='int((nf+2)/2) * W/nf * 0.18u' pd='2*int((nf+1)/2) * (W/nf + 0.18u)'
+ ps='2*int((nf+2)/2) * (W/nf + 0.18u)' nrd='0.18u / W' nrs='0.18u / W' sa=0 sb=0 sd=0 m=1
XMCN ICN ICN VSS VSS nfet_03v3 L=1u W=4u nf=1 ad='int((nf+1)/2) * W/nf * 0.18u' as='int((nf+2)/2) * W/nf * 0.18u' pd='2*int((nf+1)/2) * (W/nf + 0.18u)'
+ ps='2*int((nf+2)/2) * (W/nf + 0.18u)' nrd='0.18u / W' nrs='0.18u / W' sa=0 sb=0 sd=0 m=1
XMBP IBP IBP VDD VDD pfet_03v3 L=1u W=48u nf=1 ad='int((nf+1)/2) * W/nf * 0.18u' as='int((nf+2)/2) * W/nf * 0.18u' pd='2*int((nf+1)/2) * (W/nf + 0.18u)'
+ ps='2*int((nf+2)/2) * (W/nf + 0.18u)' nrd='0.18u / W' nrs='0.18u / W' sa=0 sb=0 sd=0 m=1
XMCP ICP ICP VDD VDD pfet_03v3 L=1u W=12u nf=1 ad='int((nf+1)/2) * W/nf * 0.18u' as='int((nf+2)/2) * W/nf * 0.18u' pd='2*int((nf+1)/2) * (W/nf + 0.18u)'
+ ps='2*int((nf+2)/2) * (W/nf + 0.18u)' nrd='0.18u / W' nrs='0.18u / W' sa=0 sb=0 sd=0 m=1
xi_b0 B0 B0B VDD VSS pfdcp_inv_3v3
xi_b1 B1 B1B VDD VSS pfdcp_inv_3v3
xi_up UP UPB VDD VSS pfdcp_inv_3v3
xi_dn DN DNB VDD VSS pfdcp_inv_3v3
xn_base IBN ICN VDD VSS DNT VSS cp_leg_n
xn_t0 IBN ICN B0 B0B DNT VSS cp_leg_n
xn_t1a IBN ICN B1 B1B DNT VSS cp_leg_n
xn_t1b IBN ICN B1 B1B DNT VSS cp_leg_n
xp_base IBP ICP VDD VSS UPT VDD cp_leg_p
xp_t0 IBP ICP B0 B0B UPT VDD cp_leg_p
xp_t1a IBP ICP B1 B1B UPT VDD cp_leg_p
xp_t1b IBP ICP B1 B1B UPT VDD cp_leg_p
XMSWDN VOUT DN DNT VSS nfet_03v3 L=0.3u W=6u nf=1 ad='int((nf+1)/2) * W/nf * 0.18u' as='int((nf+2)/2) * W/nf * 0.18u' pd='2*int((nf+1)/2) * (W/nf + 0.18u)'
+ ps='2*int((nf+2)/2) * (W/nf + 0.18u)' nrd='0.18u / W' nrs='0.18u / W' sa=0 sb=0 sd=0 m=1
XMDMPDN VDUMP DNB DNT VSS nfet_03v3 L=0.3u W=6u nf=1 ad='int((nf+1)/2) * W/nf * 0.18u' as='int((nf+2)/2) * W/nf * 0.18u' pd='2*int((nf+1)/2) * (W/nf + 0.18u)'
+ ps='2*int((nf+2)/2) * (W/nf + 0.18u)' nrd='0.18u / W' nrs='0.18u / W' sa=0 sb=0 sd=0 m=1
XMSWUP VOUT UPB UPT VDD pfet_03v3 L=0.3u W=6u nf=1 ad='int((nf+1)/2) * W/nf * 0.18u' as='int((nf+2)/2) * W/nf * 0.18u' pd='2*int((nf+1)/2) * (W/nf + 0.18u)'
+ ps='2*int((nf+2)/2) * (W/nf + 0.18u)' nrd='0.18u / W' nrs='0.18u / W' sa=0 sb=0 sd=0 m=1
XMDMPUP VDUMP UP UPT VDD pfet_03v3 L=0.3u W=6u nf=1 ad='int((nf+1)/2) * W/nf * 0.18u' as='int((nf+2)/2) * W/nf * 0.18u' pd='2*int((nf+1)/2) * (W/nf + 0.18u)'
+ ps='2*int((nf+2)/2) * (W/nf + 0.18u)' nrd='0.18u / W' nrs='0.18u / W' sa=0 sb=0 sd=0 m=1
XMDUMN VOUT DNB VOUT VSS nfet_03v3 L=0.3u W=3u nf=1 ad='int((nf+1)/2) * W/nf * 0.18u' as='int((nf+2)/2) * W/nf * 0.18u' pd='2*int((nf+1)/2) * (W/nf + 0.18u)'
+ ps='2*int((nf+2)/2) * (W/nf + 0.18u)' nrd='0.18u / W' nrs='0.18u / W' sa=0 sb=0 sd=0 m=1
XMDUMP VOUT UP VOUT VDD pfet_03v3 L=0.3u W=3u nf=1 ad='int((nf+1)/2) * W/nf * 0.18u' as='int((nf+2)/2) * W/nf * 0.18u' pd='2*int((nf+1)/2) * (W/nf + 0.18u)'
+ ps='2*int((nf+2)/2) * (W/nf + 0.18u)' nrd='0.18u / W' nrs='0.18u / W' sa=0 sb=0 sd=0 m=1
xbuf VOUT IBN IBP VDUMP VDD VSS cp_dumpbuf
.ends

* expanding   symbol:  vco_bias.sym # of pins=8
** sym_path: design/vco_bias.sym
** sch_path: design/vco_bias.sch
.subckt vco_bias VCTRL B0 B1 B2 VBP VBN VDD VSS
*.ipin VCTRL
*.ipin B0
*.ipin B1
*.ipin B2
*.iopin VBP
*.iopin VBN
*.iopin VDD
*.iopin VSS
XMP1 NA VBPC VDD VDD pfet_03v3 L=1u W=10u nf=1 ad='int((nf+1)/2) * W/nf * 0.18u' as='int((nf+2)/2) * W/nf * 0.18u' pd='2*int((nf+1)/2) * (W/nf + 0.18u)'
+ ps='2*int((nf+2)/2) * (W/nf + 0.18u)' nrd='0.18u / W' nrs='0.18u / W' sa=0 sb=0 sd=0 m=1
XMP2 VBPC VBPC VDD VDD pfet_03v3 L=1u W=10u nf=1 ad='int((nf+1)/2) * W/nf * 0.18u' as='int((nf+2)/2) * W/nf * 0.18u' pd='2*int((nf+1)/2) * (W/nf + 0.18u)'
+ ps='2*int((nf+2)/2) * (W/nf + 0.18u)' nrd='0.18u / W' nrs='0.18u / W' sa=0 sb=0 sd=0 m=1
XMN1 NA NA VSS VSS nfet_03v3 L=1u W=1.4u nf=1 ad='int((nf+1)/2) * W/nf * 0.18u' as='int((nf+2)/2) * W/nf * 0.18u' pd='2*int((nf+1)/2) * (W/nf + 0.18u)'
+ ps='2*int((nf+2)/2) * (W/nf + 0.18u)' nrd='0.18u / W' nrs='0.18u / W' sa=0 sb=0 sd=0 m=1
XMN2 VBPC NA NC VSS nfet_03v3 L=1u W=5.6u nf=1 ad='int((nf+1)/2) * W/nf * 0.18u' as='int((nf+2)/2) * W/nf * 0.18u' pd='2*int((nf+1)/2) * (W/nf + 0.18u)'
+ ps='2*int((nf+2)/2) * (W/nf + 0.18u)' nrd='0.18u / W' nrs='0.18u / W' sa=0 sb=0 sd=0 m=1
XRCG NC VSS VSS ppolyf_u_3k r_width=1u r_length=5.6u m=1
XMSU1 NSU VSS VDD VDD pfet_03v3 L=20u W=0.22u nf=1 ad='int((nf+1)/2) * W/nf * 0.18u' as='int((nf+2)/2) * W/nf * 0.18u' pd='2*int((nf+1)/2) * (W/nf + 0.18u)'
+ ps='2*int((nf+2)/2) * (W/nf + 0.18u)' nrd='0.18u / W' nrs='0.18u / W' sa=0 sb=0 sd=0 m=1
XMSU2 NSU NA VSS VSS nfet_03v3 L=1u W=2u nf=1 ad='int((nf+1)/2) * W/nf * 0.18u' as='int((nf+2)/2) * W/nf * 0.18u' pd='2*int((nf+1)/2) * (W/nf + 0.18u)'
+ ps='2*int((nf+2)/2) * (W/nf + 0.18u)' nrd='0.18u / W' nrs='0.18u / W' sa=0 sb=0 sd=0 m=1
XMSU3 VBPC NSU VSS VSS nfet_03v3 L=1u W=1u nf=1 ad='int((nf+1)/2) * W/nf * 0.18u' as='int((nf+2)/2) * W/nf * 0.18u' pd='2*int((nf+1)/2) * (W/nf + 0.18u)'
+ ps='2*int((nf+2)/2) * (W/nf + 0.18u)' nrd='0.18u / W' nrs='0.18u / W' sa=0 sb=0 sd=0 m=1
XMPR VFIX VBPC VDD VDD pfet_03v3 L=1u W=2.5u nf=1 ad='int((nf+1)/2) * W/nf * 0.18u' as='int((nf+2)/2) * W/nf * 0.18u' pd='2*int((nf+1)/2) * (W/nf + 0.18u)'
+ ps='2*int((nf+2)/2) * (W/nf + 0.18u)' nrd='0.18u / W' nrs='0.18u / W' sa=0 sb=0 sd=0 m=1
XMD1 VFIX VFIX NMD VSS nfet_03v3 L=1u W=2u nf=1 ad='int((nf+1)/2) * W/nf * 0.18u' as='int((nf+2)/2) * W/nf * 0.18u' pd='2*int((nf+1)/2) * (W/nf + 0.18u)'
+ ps='2*int((nf+2)/2) * (W/nf + 0.18u)' nrd='0.18u / W' nrs='0.18u / W' sa=0 sb=0 sd=0 m=1
XMD2 NMD NMD VSS VSS nfet_03v3 L=1u W=2u nf=1 ad='int((nf+1)/2) * W/nf * 0.18u' as='int((nf+2)/2) * W/nf * 0.18u' pd='2*int((nf+1)/2) * (W/nf + 0.18u)'
+ ps='2*int((nf+2)/2) * (W/nf + 0.18u)' nrd='0.18u / W' nrs='0.18u / W' sa=0 sb=0 sd=0 m=1
XMOFF VBP0 VFIX NOFF VSS nfet_03v3 L=1u W=10u nf=1 ad='int((nf+1)/2) * W/nf * 0.18u' as='int((nf+2)/2) * W/nf * 0.18u' pd='2*int((nf+1)/2) * (W/nf + 0.18u)'
+ ps='2*int((nf+2)/2) * (W/nf + 0.18u)' nrd='0.18u / W' nrs='0.18u / W' sa=0 sb=0 sd=0 m=1
XROFF NOFF VSS VSS ppolyf_u_3k r_width=1u r_length=33u m=1
XMVI VBP0 VCTRL NVI VSS nfet_03v3 L=1u W=10u nf=1 ad='int((nf+1)/2) * W/nf * 0.18u' as='int((nf+2)/2) * W/nf * 0.18u' pd='2*int((nf+1)/2) * (W/nf + 0.18u)'
+ ps='2*int((nf+2)/2) * (W/nf + 0.18u)' nrd='0.18u / W' nrs='0.18u / W' sa=0 sb=0 sd=0 m=1
XRDEG NVI VSS VSS ppolyf_u_3k r_width=1u r_length=33u m=1
XMSUM VBP0 VBP0 VDD VDD pfet_03v3 L=1u W=60u nf=4 ad='int((nf+1)/2) * W/nf * 0.18u' as='int((nf+2)/2) * W/nf * 0.18u' pd='2*int((nf+1)/2) * (W/nf + 0.18u)'
+ ps='2*int((nf+2)/2) * (W/nf + 0.18u)' nrd='0.18u / W' nrs='0.18u / W' sa=0 sb=0 sd=0 m=1
XMIP0 B0B B0 VDD VDD pfet_03v3 L=0.28u W=2u nf=1 ad='int((nf+1)/2) * W/nf * 0.18u' as='int((nf+2)/2) * W/nf * 0.18u' pd='2*int((nf+1)/2) * (W/nf + 0.18u)'
+ ps='2*int((nf+2)/2) * (W/nf + 0.18u)' nrd='0.18u / W' nrs='0.18u / W' sa=0 sb=0 sd=0 m=1
XMIN0 B0B B0 VSS VSS nfet_03v3 L=0.28u W=1u nf=1 ad='int((nf+1)/2) * W/nf * 0.18u' as='int((nf+2)/2) * W/nf * 0.18u' pd='2*int((nf+1)/2) * (W/nf + 0.18u)'
+ ps='2*int((nf+2)/2) * (W/nf + 0.18u)' nrd='0.18u / W' nrs='0.18u / W' sa=0 sb=0 sd=0 m=1
XMIP1 B1B B1 VDD VDD pfet_03v3 L=0.28u W=2u nf=1 ad='int((nf+1)/2) * W/nf * 0.18u' as='int((nf+2)/2) * W/nf * 0.18u' pd='2*int((nf+1)/2) * (W/nf + 0.18u)'
+ ps='2*int((nf+2)/2) * (W/nf + 0.18u)' nrd='0.18u / W' nrs='0.18u / W' sa=0 sb=0 sd=0 m=1
XMIN1 B1B B1 VSS VSS nfet_03v3 L=0.28u W=1u nf=1 ad='int((nf+1)/2) * W/nf * 0.18u' as='int((nf+2)/2) * W/nf * 0.18u' pd='2*int((nf+1)/2) * (W/nf + 0.18u)'
+ ps='2*int((nf+2)/2) * (W/nf + 0.18u)' nrd='0.18u / W' nrs='0.18u / W' sa=0 sb=0 sd=0 m=1
XMIP2 B2B B2 VDD VDD pfet_03v3 L=0.28u W=2u nf=1 ad='int((nf+1)/2) * W/nf * 0.18u' as='int((nf+2)/2) * W/nf * 0.18u' pd='2*int((nf+1)/2) * (W/nf + 0.18u)'
+ ps='2*int((nf+2)/2) * (W/nf + 0.18u)' nrd='0.18u / W' nrs='0.18u / W' sa=0 sb=0 sd=0 m=1
XMIN2 B2B B2 VSS VSS nfet_03v3 L=0.28u W=1u nf=1 ad='int((nf+1)/2) * W/nf * 0.18u' as='int((nf+2)/2) * W/nf * 0.18u' pd='2*int((nf+1)/2) * (W/nf + 0.18u)'
+ ps='2*int((nf+2)/2) * (W/nf + 0.18u)' nrd='0.18u / W' nrs='0.18u / W' sa=0 sb=0 sd=0 m=1
XMA0 VBN1 VBP0 VDD VDD pfet_03v3 L=1u W=26.5u nf=2 ad='int((nf+1)/2) * W/nf * 0.18u' as='int((nf+2)/2) * W/nf * 0.18u' pd='2*int((nf+1)/2) * (W/nf + 0.18u)'
+ ps='2*int((nf+2)/2) * (W/nf + 0.18u)' nrd='0.18u / W' nrs='0.18u / W' sa=0 sb=0 sd=0 m=1
XMA1 VBN1 GA VDD VDD pfet_03v3 L=1u W=17.225u nf=2 ad='int((nf+1)/2) * W/nf * 0.18u' as='int((nf+2)/2) * W/nf * 0.18u' pd='2*int((nf+1)/2) * (W/nf + 0.18u)'
+ ps='2*int((nf+2)/2) * (W/nf + 0.18u)' nrd='0.18u / W' nrs='0.18u / W' sa=0 sb=0 sd=0 m=1
XMSWA0 GA B0B VBP0 VDD pfet_03v3 L=0.5u W=2u nf=1 ad='int((nf+1)/2) * W/nf * 0.18u' as='int((nf+2)/2) * W/nf * 0.18u' pd='2*int((nf+1)/2) * (W/nf + 0.18u)'
+ ps='2*int((nf+2)/2) * (W/nf + 0.18u)' nrd='0.18u / W' nrs='0.18u / W' sa=0 sb=0 sd=0 m=1
XMSWA1 GA B0 VDD VDD pfet_03v3 L=0.5u W=2u nf=1 ad='int((nf+1)/2) * W/nf * 0.18u' as='int((nf+2)/2) * W/nf * 0.18u' pd='2*int((nf+1)/2) * (W/nf + 0.18u)'
+ ps='2*int((nf+2)/2) * (W/nf + 0.18u)' nrd='0.18u / W' nrs='0.18u / W' sa=0 sb=0 sd=0 m=1
XMDA VBN1 VBN1 VSS VSS nfet_03v3 L=1u W=10u nf=1 ad='int((nf+1)/2) * W/nf * 0.18u' as='int((nf+2)/2) * W/nf * 0.18u' pd='2*int((nf+1)/2) * (W/nf + 0.18u)'
+ ps='2*int((nf+2)/2) * (W/nf + 0.18u)' nrd='0.18u / W' nrs='0.18u / W' sa=0 sb=0 sd=0 m=1
XMB0 VBP2 VBN1 VSS VSS nfet_03v3 L=1u W=5u nf=1 ad='int((nf+1)/2) * W/nf * 0.18u' as='int((nf+2)/2) * W/nf * 0.18u' pd='2*int((nf+1)/2) * (W/nf + 0.18u)'
+ ps='2*int((nf+2)/2) * (W/nf + 0.18u)' nrd='0.18u / W' nrs='0.18u / W' sa=0 sb=0 sd=0 m=1
XMB1 VBP2 GB VSS VSS nfet_03v3 L=1u W=8.6125u nf=1 ad='int((nf+1)/2) * W/nf * 0.18u' as='int((nf+2)/2) * W/nf * 0.18u' pd='2*int((nf+1)/2) * (W/nf + 0.18u)'
+ ps='2*int((nf+2)/2) * (W/nf + 0.18u)' nrd='0.18u / W' nrs='0.18u / W' sa=0 sb=0 sd=0 m=1
XMSWB0 GB B1 VBN1 VSS nfet_03v3 L=0.5u W=2u nf=1 ad='int((nf+1)/2) * W/nf * 0.18u' as='int((nf+2)/2) * W/nf * 0.18u' pd='2*int((nf+1)/2) * (W/nf + 0.18u)'
+ ps='2*int((nf+2)/2) * (W/nf + 0.18u)' nrd='0.18u / W' nrs='0.18u / W' sa=0 sb=0 sd=0 m=1
XMSWB1 GB B1B VSS VSS nfet_03v3 L=0.5u W=2u nf=1 ad='int((nf+1)/2) * W/nf * 0.18u' as='int((nf+2)/2) * W/nf * 0.18u' pd='2*int((nf+1)/2) * (W/nf + 0.18u)'
+ ps='2*int((nf+2)/2) * (W/nf + 0.18u)' nrd='0.18u / W' nrs='0.18u / W' sa=0 sb=0 sd=0 m=1
XMDB VBP2 VBP2 VDD VDD pfet_03v3 L=1u W=20u nf=1 ad='int((nf+1)/2) * W/nf * 0.18u' as='int((nf+2)/2) * W/nf * 0.18u' pd='2*int((nf+1)/2) * (W/nf + 0.18u)'
+ ps='2*int((nf+2)/2) * (W/nf + 0.18u)' nrd='0.18u / W' nrs='0.18u / W' sa=0 sb=0 sd=0 m=1
XMC0 VBN VBP2 VDD VDD pfet_03v3 L=1u W=12.3u nf=1 ad='int((nf+1)/2) * W/nf * 0.18u' as='int((nf+2)/2) * W/nf * 0.18u' pd='2*int((nf+1)/2) * (W/nf + 0.18u)'
+ ps='2*int((nf+2)/2) * (W/nf + 0.18u)' nrd='0.18u / W' nrs='0.18u / W' sa=0 sb=0 sd=0 m=1
XMC1 VBN GC VDD VDD pfet_03v3 L=1u W=78.87u nf=8 ad='int((nf+1)/2) * W/nf * 0.18u' as='int((nf+2)/2) * W/nf * 0.18u' pd='2*int((nf+1)/2) * (W/nf + 0.18u)'
+ ps='2*int((nf+2)/2) * (W/nf + 0.18u)' nrd='0.18u / W' nrs='0.18u / W' sa=0 sb=0 sd=0 m=1
XMSWC0 GC B2B VBP2 VDD pfet_03v3 L=0.5u W=2u nf=1 ad='int((nf+1)/2) * W/nf * 0.18u' as='int((nf+2)/2) * W/nf * 0.18u' pd='2*int((nf+1)/2) * (W/nf + 0.18u)'
+ ps='2*int((nf+2)/2) * (W/nf + 0.18u)' nrd='0.18u / W' nrs='0.18u / W' sa=0 sb=0 sd=0 m=1
XMSWC1 GC B2 VDD VDD pfet_03v3 L=0.5u W=2u nf=1 ad='int((nf+1)/2) * W/nf * 0.18u' as='int((nf+2)/2) * W/nf * 0.18u' pd='2*int((nf+1)/2) * (W/nf + 0.18u)'
+ ps='2*int((nf+2)/2) * (W/nf + 0.18u)' nrd='0.18u / W' nrs='0.18u / W' sa=0 sb=0 sd=0 m=1
XMDN VBN VBN VSS VSS nfet_03v3 L=0.5u W=4u nf=1 ad='int((nf+1)/2) * W/nf * 0.18u' as='int((nf+2)/2) * W/nf * 0.18u' pd='2*int((nf+1)/2) * (W/nf + 0.18u)'
+ ps='2*int((nf+2)/2) * (W/nf + 0.18u)' nrd='0.18u / W' nrs='0.18u / W' sa=0 sb=0 sd=0 m=1
XMMN VBP VBN VSS VSS nfet_03v3 L=0.5u W=4u nf=1 ad='int((nf+1)/2) * W/nf * 0.18u' as='int((nf+2)/2) * W/nf * 0.18u' pd='2*int((nf+1)/2) * (W/nf + 0.18u)'
+ ps='2*int((nf+2)/2) * (W/nf + 0.18u)' nrd='0.18u / W' nrs='0.18u / W' sa=0 sb=0 sd=0 m=1
XMDP VBP VBP VDD VDD pfet_03v3 L=0.5u W=10u nf=1 ad='int((nf+1)/2) * W/nf * 0.18u' as='int((nf+2)/2) * W/nf * 0.18u' pd='2*int((nf+1)/2) * (W/nf + 0.18u)'
+ ps='2*int((nf+2)/2) * (W/nf + 0.18u)' nrd='0.18u / W' nrs='0.18u / W' sa=0 sb=0 sd=0 m=1
.ends

* expanding   symbol:  vco_stage.sym # of pins=6
** sym_path: design/vco_stage.sym
** sch_path: design/vco_stage.sch
.subckt vco_stage A Y VDD VSS VBP VBN
*.ipin A
*.opin Y
*.iopin VDD
*.iopin VSS
*.iopin VBP
*.iopin VBN
XMPH NH VBP VDD VDD pfet_03v3 L=0.5u W=10u nf=1 ad='int((nf+1)/2) * W/nf * 0.18u' as='int((nf+2)/2) * W/nf * 0.18u' pd='2*int((nf+1)/2) * (W/nf + 0.18u)'
+ ps='2*int((nf+2)/2) * (W/nf + 0.18u)' nrd='0.18u / W' nrs='0.18u / W' sa=0 sb=0 sd=0 m=1
XMP Y A NH VDD pfet_03v3 L=0.28u W=5u nf=1 ad='int((nf+1)/2) * W/nf * 0.18u' as='int((nf+2)/2) * W/nf * 0.18u' pd='2*int((nf+1)/2) * (W/nf + 0.18u)'
+ ps='2*int((nf+2)/2) * (W/nf + 0.18u)' nrd='0.18u / W' nrs='0.18u / W' sa=0 sb=0 sd=0 m=1
XMN Y A NT VSS nfet_03v3 L=0.28u W=2u nf=1 ad='int((nf+1)/2) * W/nf * 0.18u' as='int((nf+2)/2) * W/nf * 0.18u' pd='2*int((nf+1)/2) * (W/nf + 0.18u)'
+ ps='2*int((nf+2)/2) * (W/nf + 0.18u)' nrd='0.18u / W' nrs='0.18u / W' sa=0 sb=0 sd=0 m=1
XMNT NT VBN VSS VSS nfet_03v3 L=0.5u W=4u nf=1 ad='int((nf+1)/2) * W/nf * 0.18u' as='int((nf+2)/2) * W/nf * 0.18u' pd='2*int((nf+1)/2) * (W/nf + 0.18u)'
+ ps='2*int((nf+2)/2) * (W/nf + 0.18u)' nrd='0.18u / W' nrs='0.18u / W' sa=0 sb=0 sd=0 m=1
.ends

* expanding   symbol:  div23_cell.sym # of pins=7
** sym_path: design/div23_cell.sym
** sch_path: design/div23_cell.sch
.subckt div23_cell CKIN MODIN P CKOUT MODOUT VDD VSS
*.ipin CKIN
*.ipin MODIN
*.ipin P
*.opin CKOUT
*.opin MODOUT
*.iopin VDD
*.iopin VSS
XN3 MODIN P MODOUT SB VDD VSS nand3_3v3
XN2Q QB SB DQN VDD VSS nand2_3v3
XIQ DQN DQ VDD VSS inv_3v3
XFQ DQ CKIN Q QB VDD VSS dff_tg_3v3
XICKO QB CKOUT VDD VSS inv2x_3v3
XN2M MODIN Q NMO VDD VSS nand2_3v3
XIM NMO DMO VDD VSS inv_3v3
XFMO DMO CKIN MODOUT MOB VDD VSS dff_tg_3v3
.ends

* expanding   symbol:  nor2_3v3.sym # of pins=5
** sym_path: design/nor2_3v3.sym
** sch_path: design/nor2_3v3.sch
.subckt nor2_3v3 A B Y VDD VSS
*.ipin A
*.ipin B
*.opin Y
*.iopin VDD
*.iopin VSS
XMPA PMID A VDD VDD pfet_03v3 L=0.28u W=5u nf=1 ad='int((nf+1)/2) * W/nf * 0.18u' as='int((nf+2)/2) * W/nf * 0.18u' pd='2*int((nf+1)/2) * (W/nf + 0.18u)'
+ ps='2*int((nf+2)/2) * (W/nf + 0.18u)' nrd='0.18u / W' nrs='0.18u / W' sa=0 sb=0 sd=0 m=1
XMPB Y B PMID VDD pfet_03v3 L=0.28u W=5u nf=1 ad='int((nf+1)/2) * W/nf * 0.18u' as='int((nf+2)/2) * W/nf * 0.18u' pd='2*int((nf+1)/2) * (W/nf + 0.18u)'
+ ps='2*int((nf+2)/2) * (W/nf + 0.18u)' nrd='0.18u / W' nrs='0.18u / W' sa=0 sb=0 sd=0 m=1
XMNA Y A VSS VSS nfet_03v3 L=0.28u W=1u nf=1 ad='int((nf+1)/2) * W/nf * 0.18u' as='int((nf+2)/2) * W/nf * 0.18u' pd='2*int((nf+1)/2) * (W/nf + 0.18u)'
+ ps='2*int((nf+2)/2) * (W/nf + 0.18u)' nrd='0.18u / W' nrs='0.18u / W' sa=0 sb=0 sd=0 m=1
XMNB Y B VSS VSS nfet_03v3 L=0.28u W=1u nf=1 ad='int((nf+1)/2) * W/nf * 0.18u' as='int((nf+2)/2) * W/nf * 0.18u' pd='2*int((nf+1)/2) * (W/nf + 0.18u)'
+ ps='2*int((nf+2)/2) * (W/nf + 0.18u)' nrd='0.18u / W' nrs='0.18u / W' sa=0 sb=0 sd=0 m=1
.ends

* expanding   symbol:  inv_3v3.sym # of pins=4
** sym_path: design/inv_3v3.sym
** sch_path: design/inv_3v3.sch
.subckt inv_3v3 A Y VDD VSS
*.ipin A
*.opin Y
*.iopin VDD
*.iopin VSS
XMP Y A VDD VDD pfet_03v3 L=0.28u W=2.5u nf=1 ad='int((nf+1)/2) * W/nf * 0.18u' as='int((nf+2)/2) * W/nf * 0.18u' pd='2*int((nf+1)/2) * (W/nf + 0.18u)'
+ ps='2*int((nf+2)/2) * (W/nf + 0.18u)' nrd='0.18u / W' nrs='0.18u / W' sa=0 sb=0 sd=0 m=1
XMN Y A VSS VSS nfet_03v3 L=0.28u W=1u nf=1 ad='int((nf+1)/2) * W/nf * 0.18u' as='int((nf+2)/2) * W/nf * 0.18u' pd='2*int((nf+1)/2) * (W/nf + 0.18u)'
+ ps='2*int((nf+2)/2) * (W/nf + 0.18u)' nrd='0.18u / W' nrs='0.18u / W' sa=0 sb=0 sd=0 m=1
.ends

* expanding   symbol:  nand2_3v3.sym # of pins=5
** sym_path: design/nand2_3v3.sym
** sch_path: design/nand2_3v3.sch
.subckt nand2_3v3 A B Y VDD VSS
*.ipin A
*.ipin B
*.opin Y
*.iopin VDD
*.iopin VSS
XMPA Y A VDD VDD pfet_03v3 L=0.28u W=2.5u nf=1 ad='int((nf+1)/2) * W/nf * 0.18u' as='int((nf+2)/2) * W/nf * 0.18u' pd='2*int((nf+1)/2) * (W/nf + 0.18u)'
+ ps='2*int((nf+2)/2) * (W/nf + 0.18u)' nrd='0.18u / W' nrs='0.18u / W' sa=0 sb=0 sd=0 m=1
XMPB Y B VDD VDD pfet_03v3 L=0.28u W=2.5u nf=1 ad='int((nf+1)/2) * W/nf * 0.18u' as='int((nf+2)/2) * W/nf * 0.18u' pd='2*int((nf+1)/2) * (W/nf + 0.18u)'
+ ps='2*int((nf+2)/2) * (W/nf + 0.18u)' nrd='0.18u / W' nrs='0.18u / W' sa=0 sb=0 sd=0 m=1
XMNA Y A NMID VSS nfet_03v3 L=0.28u W=2u nf=1 ad='int((nf+1)/2) * W/nf * 0.18u' as='int((nf+2)/2) * W/nf * 0.18u' pd='2*int((nf+1)/2) * (W/nf + 0.18u)'
+ ps='2*int((nf+2)/2) * (W/nf + 0.18u)' nrd='0.18u / W' nrs='0.18u / W' sa=0 sb=0 sd=0 m=1
XMNB NMID B VSS VSS nfet_03v3 L=0.28u W=2u nf=1 ad='int((nf+1)/2) * W/nf * 0.18u' as='int((nf+2)/2) * W/nf * 0.18u' pd='2*int((nf+1)/2) * (W/nf + 0.18u)'
+ ps='2*int((nf+2)/2) * (W/nf + 0.18u)' nrd='0.18u / W' nrs='0.18u / W' sa=0 sb=0 sd=0 m=1
.ends

* expanding   symbol:  nand3_3v3.sym # of pins=6
** sym_path: design/nand3_3v3.sym
** sch_path: design/nand3_3v3.sch
.subckt nand3_3v3 A B C Y VDD VSS
*.ipin A
*.ipin B
*.ipin C
*.opin Y
*.iopin VDD
*.iopin VSS
XMPA Y A VDD VDD pfet_03v3 L=0.28u W=2.5u nf=1 ad='int((nf+1)/2) * W/nf * 0.18u' as='int((nf+2)/2) * W/nf * 0.18u' pd='2*int((nf+1)/2) * (W/nf + 0.18u)'
+ ps='2*int((nf+2)/2) * (W/nf + 0.18u)' nrd='0.18u / W' nrs='0.18u / W' sa=0 sb=0 sd=0 m=1
XMPB Y B VDD VDD pfet_03v3 L=0.28u W=2.5u nf=1 ad='int((nf+1)/2) * W/nf * 0.18u' as='int((nf+2)/2) * W/nf * 0.18u' pd='2*int((nf+1)/2) * (W/nf + 0.18u)'
+ ps='2*int((nf+2)/2) * (W/nf + 0.18u)' nrd='0.18u / W' nrs='0.18u / W' sa=0 sb=0 sd=0 m=1
XMPC Y C VDD VDD pfet_03v3 L=0.28u W=2.5u nf=1 ad='int((nf+1)/2) * W/nf * 0.18u' as='int((nf+2)/2) * W/nf * 0.18u' pd='2*int((nf+1)/2) * (W/nf + 0.18u)'
+ ps='2*int((nf+2)/2) * (W/nf + 0.18u)' nrd='0.18u / W' nrs='0.18u / W' sa=0 sb=0 sd=0 m=1
XMNA Y A NM1 VSS nfet_03v3 L=0.28u W=3u nf=1 ad='int((nf+1)/2) * W/nf * 0.18u' as='int((nf+2)/2) * W/nf * 0.18u' pd='2*int((nf+1)/2) * (W/nf + 0.18u)'
+ ps='2*int((nf+2)/2) * (W/nf + 0.18u)' nrd='0.18u / W' nrs='0.18u / W' sa=0 sb=0 sd=0 m=1
XMNB NM1 B NM2 VSS nfet_03v3 L=0.28u W=3u nf=1 ad='int((nf+1)/2) * W/nf * 0.18u' as='int((nf+2)/2) * W/nf * 0.18u' pd='2*int((nf+1)/2) * (W/nf + 0.18u)'
+ ps='2*int((nf+2)/2) * (W/nf + 0.18u)' nrd='0.18u / W' nrs='0.18u / W' sa=0 sb=0 sd=0 m=1
XMNC NM2 C VSS VSS nfet_03v3 L=0.28u W=3u nf=1 ad='int((nf+1)/2) * W/nf * 0.18u' as='int((nf+2)/2) * W/nf * 0.18u' pd='2*int((nf+1)/2) * (W/nf + 0.18u)'
+ ps='2*int((nf+2)/2) * (W/nf + 0.18u)' nrd='0.18u / W' nrs='0.18u / W' sa=0 sb=0 sd=0 m=1
.ends

* expanding   symbol:  inv2x_3v3.sym # of pins=4
** sym_path: design/inv2x_3v3.sym
** sch_path: design/inv2x_3v3.sch
.subckt inv2x_3v3 A Y VDD VSS
*.ipin A
*.opin Y
*.iopin VDD
*.iopin VSS
XMP Y A VDD VDD pfet_03v3 L=0.28u W=5u nf=1 ad='int((nf+1)/2) * W/nf * 0.18u' as='int((nf+2)/2) * W/nf * 0.18u' pd='2*int((nf+1)/2) * (W/nf + 0.18u)'
+ ps='2*int((nf+2)/2) * (W/nf + 0.18u)' nrd='0.18u / W' nrs='0.18u / W' sa=0 sb=0 sd=0 m=1
XMN Y A VSS VSS nfet_03v3 L=0.28u W=2u nf=1 ad='int((nf+1)/2) * W/nf * 0.18u' as='int((nf+2)/2) * W/nf * 0.18u' pd='2*int((nf+1)/2) * (W/nf + 0.18u)'
+ ps='2*int((nf+2)/2) * (W/nf + 0.18u)' nrd='0.18u / W' nrs='0.18u / W' sa=0 sb=0 sd=0 m=1
.ends

* expanding   symbol:  dff_tg_3v3.sym # of pins=6
** sym_path: design/dff_tg_3v3.sym
** sch_path: design/dff_tg_3v3.sch
.subckt dff_tg_3v3 D CK Q QB VDD VSS
*.ipin D
*.ipin CK
*.opin Q
*.opin QB
*.iopin VDD
*.iopin VSS
XICKB CK CKB VDD VSS inv_3v3
XICKBB CKB CKBB VDD VSS inv_3v3
XTGMI D NM CKB CKBB VDD VSS tgate_3v3
XIA NM NMA VDD VSS inv_3v3
XIB NMA NMB VDD VSS inv_3v3
XTGMF NMB NM CKBB CKB VDD VSS tgate_3v3
XTGSI NMA NS CKBB CKB VDD VSS tgate_3v3
XIC NS Q VDD VSS inv_3v3
XID Q QB VDD VSS inv_3v3
XTGSF QB NS CKB CKBB VDD VSS tgate_3v3
.ends

* expanding   symbol:  xor2_3v3.sym # of pins=5
** sym_path: design/xor2_3v3.sym
** sch_path: design/xor2_3v3.sch
.subckt xor2_3v3 A B Y VDD VSS
*.ipin A
*.ipin B
*.opin Y
*.iopin VDD
*.iopin VSS
XG1 A B N1 VDD VSS nand2_3v3
XG2 A N1 N2 VDD VSS nand2_3v3
XG3 B N1 N3 VDD VSS nand2_3v3
XG4 N2 N3 Y VDD VSS nand2_3v3
.ends

* expanding   symbol:  delaywin_3v3.sym # of pins=4
** sym_path: design/delaywin_3v3.sym
** sch_path: design/delaywin_3v3.sch
.subckt delaywin_3v3 A Y VDD VSS
*.ipin A
*.opin Y
*.iopin VDD
*.iopin VSS
XI1 A D1 VDD VSS inv_3v3
XMC1 VSS D1 VSS VSS nfet_03v3 L=2u W=8u nf=1 ad='int((nf+1)/2) * W/nf * 0.18u' as='int((nf+2)/2) * W/nf * 0.18u' pd='2*int((nf+1)/2) * (W/nf + 0.18u)'
+ ps='2*int((nf+2)/2) * (W/nf + 0.18u)' nrd='0.18u / W' nrs='0.18u / W' sa=0 sb=0 sd=0 m=1
XI2 D1 D2 VDD VSS inv_3v3
XMC2 VSS D2 VSS VSS nfet_03v3 L=2u W=8u nf=1 ad='int((nf+1)/2) * W/nf * 0.18u' as='int((nf+2)/2) * W/nf * 0.18u' pd='2*int((nf+1)/2) * (W/nf + 0.18u)'
+ ps='2*int((nf+2)/2) * (W/nf + 0.18u)' nrd='0.18u / W' nrs='0.18u / W' sa=0 sb=0 sd=0 m=1
XI3 D2 D3 VDD VSS inv_3v3
XMC3 VSS D3 VSS VSS nfet_03v3 L=2u W=8u nf=1 ad='int((nf+1)/2) * W/nf * 0.18u' as='int((nf+2)/2) * W/nf * 0.18u' pd='2*int((nf+1)/2) * (W/nf + 0.18u)'
+ ps='2*int((nf+2)/2) * (W/nf + 0.18u)' nrd='0.18u / W' nrs='0.18u / W' sa=0 sb=0 sd=0 m=1
XI4 D3 Y VDD VSS inv_3v3
XMC4 VSS Y VSS VSS nfet_03v3 L=2u W=8u nf=1 ad='int((nf+1)/2) * W/nf * 0.18u' as='int((nf+2)/2) * W/nf * 0.18u' pd='2*int((nf+1)/2) * (W/nf + 0.18u)'
+ ps='2*int((nf+2)/2) * (W/nf + 0.18u)' nrd='0.18u / W' nrs='0.18u / W' sa=0 sb=0 sd=0 m=1
.ends

* expanding   symbol:  schmitt_3v3.sym # of pins=4
** sym_path: design/schmitt_3v3.sym
** sch_path: design/schmitt_3v3.sch
.subckt schmitt_3v3 A Y VDD VSS
*.ipin A
*.opin Y
*.iopin VDD
*.iopin VSS
XMP1 P1 A VDD VDD pfet_03v3 L=0.28u W=2.5u nf=1 ad='int((nf+1)/2) * W/nf * 0.18u' as='int((nf+2)/2) * W/nf * 0.18u' pd='2*int((nf+1)/2) * (W/nf + 0.18u)'
+ ps='2*int((nf+2)/2) * (W/nf + 0.18u)' nrd='0.18u / W' nrs='0.18u / W' sa=0 sb=0 sd=0 m=1
XMP2 Y A P1 VDD pfet_03v3 L=0.28u W=2.5u nf=1 ad='int((nf+1)/2) * W/nf * 0.18u' as='int((nf+2)/2) * W/nf * 0.18u' pd='2*int((nf+1)/2) * (W/nf + 0.18u)'
+ ps='2*int((nf+2)/2) * (W/nf + 0.18u)' nrd='0.18u / W' nrs='0.18u / W' sa=0 sb=0 sd=0 m=1
XMP3 VSS Y P1 VDD pfet_03v3 L=0.28u W=1.2u nf=1 ad='int((nf+1)/2) * W/nf * 0.18u' as='int((nf+2)/2) * W/nf * 0.18u' pd='2*int((nf+1)/2) * (W/nf + 0.18u)'
+ ps='2*int((nf+2)/2) * (W/nf + 0.18u)' nrd='0.18u / W' nrs='0.18u / W' sa=0 sb=0 sd=0 m=1
XMN1 N1 A VSS VSS nfet_03v3 L=0.28u W=1u nf=1 ad='int((nf+1)/2) * W/nf * 0.18u' as='int((nf+2)/2) * W/nf * 0.18u' pd='2*int((nf+1)/2) * (W/nf + 0.18u)'
+ ps='2*int((nf+2)/2) * (W/nf + 0.18u)' nrd='0.18u / W' nrs='0.18u / W' sa=0 sb=0 sd=0 m=1
XMN2 Y A N1 VSS nfet_03v3 L=0.28u W=1u nf=1 ad='int((nf+1)/2) * W/nf * 0.18u' as='int((nf+2)/2) * W/nf * 0.18u' pd='2*int((nf+1)/2) * (W/nf + 0.18u)'
+ ps='2*int((nf+2)/2) * (W/nf + 0.18u)' nrd='0.18u / W' nrs='0.18u / W' sa=0 sb=0 sd=0 m=1
XMN3 VDD Y N1 VSS nfet_03v3 L=0.28u W=0.5u nf=1 ad='int((nf+1)/2) * W/nf * 0.18u' as='int((nf+2)/2) * W/nf * 0.18u' pd='2*int((nf+1)/2) * (W/nf + 0.18u)'
+ ps='2*int((nf+2)/2) * (W/nf + 0.18u)' nrd='0.18u / W' nrs='0.18u / W' sa=0 sb=0 sd=0 m=1
.ends

* expanding   symbol:  edgedet.sym # of pins=4
** sym_path: design/edgedet.sym
** sch_path: design/edgedet.sch
.subckt edgedet X PULSE VDD VSS
*.ipin X
*.opin PULSE
*.iopin VDD
*.iopin VSS
xi1 X D1 VDD VSS pfdcp_inv_3v3
xi2 D1 D2 VDD VSS pfdcp_inv_3v3
xi3 D2 D3 VDD VSS pfdcp_inv_3v3
xi4 D3 D4 VDD VSS pfdcp_inv_3v3
xi5 D4 D5 VDD VSS pfdcp_inv_3v3
xnd X D5 NN VDD VSS pfdcp_nand2_3v3
xi6 NN PULSE VDD VSS pfdcp_inv_3v3
.ends

* expanding   symbol:  pfdcp_inv_3v3.sym # of pins=4
** sym_path: design/pfdcp_inv_3v3.sym
** sch_path: design/pfdcp_inv_3v3.sch
.subckt pfdcp_inv_3v3 A Y VDD VSS
*.ipin A
*.opin Y
*.iopin VDD
*.iopin VSS
XMP Y A VDD VDD pfet_03v3 L=0.3u W=1.5u nf=1 ad='int((nf+1)/2) * W/nf * 0.18u' as='int((nf+2)/2) * W/nf * 0.18u' pd='2*int((nf+1)/2) * (W/nf + 0.18u)'
+ ps='2*int((nf+2)/2) * (W/nf + 0.18u)' nrd='0.18u / W' nrs='0.18u / W' sa=0 sb=0 sd=0 m=1
XMN Y A VSS VSS nfet_03v3 L=0.3u W=0.5u nf=1 ad='int((nf+1)/2) * W/nf * 0.18u' as='int((nf+2)/2) * W/nf * 0.18u' pd='2*int((nf+1)/2) * (W/nf + 0.18u)'
+ ps='2*int((nf+2)/2) * (W/nf + 0.18u)' nrd='0.18u / W' nrs='0.18u / W' sa=0 sb=0 sd=0 m=1
.ends

* expanding   symbol:  srlatch.sym # of pins=6
** sym_path: design/srlatch.sym
** sch_path: design/srlatch.sch
.subckt srlatch SB RB Q QB VDD VSS
*.ipin SB
*.ipin RB
*.opin Q
*.opin QB
*.iopin VDD
*.iopin VSS
xn1 SB QB Q VDD VSS pfdcp_nand2_3v3
xn2 RB Q QB VDD VSS pfdcp_nand2_3v3
.ends

* expanding   symbol:  pfdcp_nand2_3v3.sym # of pins=5
** sym_path: design/pfdcp_nand2_3v3.sym
** sch_path: design/pfdcp_nand2_3v3.sch
.subckt pfdcp_nand2_3v3 A B Y VDD VSS
*.ipin A
*.ipin B
*.opin Y
*.iopin VDD
*.iopin VSS
XMP1 Y A VDD VDD pfet_03v3 L=0.3u W=1.5u nf=1 ad='int((nf+1)/2) * W/nf * 0.18u' as='int((nf+2)/2) * W/nf * 0.18u' pd='2*int((nf+1)/2) * (W/nf + 0.18u)'
+ ps='2*int((nf+2)/2) * (W/nf + 0.18u)' nrd='0.18u / W' nrs='0.18u / W' sa=0 sb=0 sd=0 m=1
XMP2 Y B VDD VDD pfet_03v3 L=0.3u W=1.5u nf=1 ad='int((nf+1)/2) * W/nf * 0.18u' as='int((nf+2)/2) * W/nf * 0.18u' pd='2*int((nf+1)/2) * (W/nf + 0.18u)'
+ ps='2*int((nf+2)/2) * (W/nf + 0.18u)' nrd='0.18u / W' nrs='0.18u / W' sa=0 sb=0 sd=0 m=1
XMN1 Y A NI VSS nfet_03v3 L=0.3u W=1u nf=1 ad='int((nf+1)/2) * W/nf * 0.18u' as='int((nf+2)/2) * W/nf * 0.18u' pd='2*int((nf+1)/2) * (W/nf + 0.18u)'
+ ps='2*int((nf+2)/2) * (W/nf + 0.18u)' nrd='0.18u / W' nrs='0.18u / W' sa=0 sb=0 sd=0 m=1
XMN2 NI B VSS VSS nfet_03v3 L=0.3u W=1u nf=1 ad='int((nf+1)/2) * W/nf * 0.18u' as='int((nf+2)/2) * W/nf * 0.18u' pd='2*int((nf+1)/2) * (W/nf + 0.18u)'
+ ps='2*int((nf+2)/2) * (W/nf + 0.18u)' nrd='0.18u / W' nrs='0.18u / W' sa=0 sb=0 sd=0 m=1
.ends

* expanding   symbol:  cp_leg_n.sym # of pins=6
** sym_path: design/cp_leg_n.sym
** sch_path: design/cp_leg_n.sch
.subckt cp_leg_n VBN VCASCN EN ENB TAIL VSS
*.ipin VBN
*.ipin VCASCN
*.ipin EN
*.ipin ENB
*.iopin TAIL
*.iopin VSS
XMEN BG EN VBN VSS nfet_03v3 L=0.3u W=1u nf=1 ad='int((nf+1)/2) * W/nf * 0.18u' as='int((nf+2)/2) * W/nf * 0.18u' pd='2*int((nf+1)/2) * (W/nf + 0.18u)'
+ ps='2*int((nf+2)/2) * (W/nf + 0.18u)' nrd='0.18u / W' nrs='0.18u / W' sa=0 sb=0 sd=0 m=1
XMDIS BG ENB VSS VSS nfet_03v3 L=0.3u W=1u nf=1 ad='int((nf+1)/2) * W/nf * 0.18u' as='int((nf+2)/2) * W/nf * 0.18u' pd='2*int((nf+1)/2) * (W/nf + 0.18u)'
+ ps='2*int((nf+2)/2) * (W/nf + 0.18u)' nrd='0.18u / W' nrs='0.18u / W' sa=0 sb=0 sd=0 m=1
XMBOT MID BG VSS VSS nfet_03v3 L=1u W=4u nf=1 ad='int((nf+1)/2) * W/nf * 0.18u' as='int((nf+2)/2) * W/nf * 0.18u' pd='2*int((nf+1)/2) * (W/nf + 0.18u)'
+ ps='2*int((nf+2)/2) * (W/nf + 0.18u)' nrd='0.18u / W' nrs='0.18u / W' sa=0 sb=0 sd=0 m=1
XMCASC TAIL VCASCN MID VSS nfet_03v3 L=1u W=4u nf=1 ad='int((nf+1)/2) * W/nf * 0.18u' as='int((nf+2)/2) * W/nf * 0.18u' pd='2*int((nf+1)/2) * (W/nf + 0.18u)'
+ ps='2*int((nf+2)/2) * (W/nf + 0.18u)' nrd='0.18u / W' nrs='0.18u / W' sa=0 sb=0 sd=0 m=1
.ends

* expanding   symbol:  cp_leg_p.sym # of pins=6
** sym_path: design/cp_leg_p.sym
** sch_path: design/cp_leg_p.sch
.subckt cp_leg_p VBP VCASCP EN ENB TAIL VDD
*.ipin VBP
*.ipin VCASCP
*.ipin EN
*.ipin ENB
*.iopin TAIL
*.iopin VDD
XMEN BG ENB VBP VDD pfet_03v3 L=0.3u W=1u nf=1 ad='int((nf+1)/2) * W/nf * 0.18u' as='int((nf+2)/2) * W/nf * 0.18u' pd='2*int((nf+1)/2) * (W/nf + 0.18u)'
+ ps='2*int((nf+2)/2) * (W/nf + 0.18u)' nrd='0.18u / W' nrs='0.18u / W' sa=0 sb=0 sd=0 m=1
XMDIS BG EN VDD VDD pfet_03v3 L=0.3u W=1u nf=1 ad='int((nf+1)/2) * W/nf * 0.18u' as='int((nf+2)/2) * W/nf * 0.18u' pd='2*int((nf+1)/2) * (W/nf + 0.18u)'
+ ps='2*int((nf+2)/2) * (W/nf + 0.18u)' nrd='0.18u / W' nrs='0.18u / W' sa=0 sb=0 sd=0 m=1
XMTOP MID BG VDD VDD pfet_03v3 L=1u W=12u nf=1 ad='int((nf+1)/2) * W/nf * 0.18u' as='int((nf+2)/2) * W/nf * 0.18u' pd='2*int((nf+1)/2) * (W/nf + 0.18u)'
+ ps='2*int((nf+2)/2) * (W/nf + 0.18u)' nrd='0.18u / W' nrs='0.18u / W' sa=0 sb=0 sd=0 m=1
XMCASC TAIL VCASCP MID VDD pfet_03v3 L=1u W=12u nf=1 ad='int((nf+1)/2) * W/nf * 0.18u' as='int((nf+2)/2) * W/nf * 0.18u' pd='2*int((nf+1)/2) * (W/nf + 0.18u)'
+ ps='2*int((nf+2)/2) * (W/nf + 0.18u)' nrd='0.18u / W' nrs='0.18u / W' sa=0 sb=0 sd=0 m=1
.ends

* expanding   symbol:  cp_dumpbuf.sym # of pins=6
** sym_path: design/cp_dumpbuf.sym
** sch_path: design/cp_dumpbuf.sch
.subckt cp_dumpbuf VREF VBN VBP VDUMP VDD VSS
*.ipin VREF
*.ipin VBN
*.ipin VBP
*.iopin VDUMP
*.iopin VDD
*.iopin VSS
XMTN NSRC VBN VSS VSS nfet_03v3 L=1u W=16u nf=1 ad='int((nf+1)/2) * W/nf * 0.18u' as='int((nf+2)/2) * W/nf * 0.18u' pd='2*int((nf+1)/2) * (W/nf + 0.18u)'
+ ps='2*int((nf+2)/2) * (W/nf + 0.18u)' nrd='0.18u / W' nrs='0.18u / W' sa=0 sb=0 sd=0 m=1
XMN1 NDA VREF NSRC VSS nfet_03v3 L=1u W=16u nf=1 ad='int((nf+1)/2) * W/nf * 0.18u' as='int((nf+2)/2) * W/nf * 0.18u' pd='2*int((nf+1)/2) * (W/nf + 0.18u)'
+ ps='2*int((nf+2)/2) * (W/nf + 0.18u)' nrd='0.18u / W' nrs='0.18u / W' sa=0 sb=0 sd=0 m=1
XMN2 VDUMP VDUMP NSRC VSS nfet_03v3 L=1u W=16u nf=1 ad='int((nf+1)/2) * W/nf * 0.18u' as='int((nf+2)/2) * W/nf * 0.18u' pd='2*int((nf+1)/2) * (W/nf + 0.18u)'
+ ps='2*int((nf+2)/2) * (W/nf + 0.18u)' nrd='0.18u / W' nrs='0.18u / W' sa=0 sb=0 sd=0 m=1
XMN3 NDA NDA VDD VDD pfet_03v3 L=1u W=24u nf=1 ad='int((nf+1)/2) * W/nf * 0.18u' as='int((nf+2)/2) * W/nf * 0.18u' pd='2*int((nf+1)/2) * (W/nf + 0.18u)'
+ ps='2*int((nf+2)/2) * (W/nf + 0.18u)' nrd='0.18u / W' nrs='0.18u / W' sa=0 sb=0 sd=0 m=1
XMN4 VDUMP NDA VDD VDD pfet_03v3 L=1u W=24u nf=1 ad='int((nf+1)/2) * W/nf * 0.18u' as='int((nf+2)/2) * W/nf * 0.18u' pd='2*int((nf+1)/2) * (W/nf + 0.18u)'
+ ps='2*int((nf+2)/2) * (W/nf + 0.18u)' nrd='0.18u / W' nrs='0.18u / W' sa=0 sb=0 sd=0 m=1
XMTP PSRC VBP VDD VDD pfet_03v3 L=1u W=48u nf=1 ad='int((nf+1)/2) * W/nf * 0.18u' as='int((nf+2)/2) * W/nf * 0.18u' pd='2*int((nf+1)/2) * (W/nf + 0.18u)'
+ ps='2*int((nf+2)/2) * (W/nf + 0.18u)' nrd='0.18u / W' nrs='0.18u / W' sa=0 sb=0 sd=0 m=1
XMP1 PDA VREF PSRC PSRC pfet_03v3 L=1u W=48u nf=1 ad='int((nf+1)/2) * W/nf * 0.18u' as='int((nf+2)/2) * W/nf * 0.18u' pd='2*int((nf+1)/2) * (W/nf + 0.18u)'
+ ps='2*int((nf+2)/2) * (W/nf + 0.18u)' nrd='0.18u / W' nrs='0.18u / W' sa=0 sb=0 sd=0 m=1
XMP2 VDUMP VDUMP PSRC PSRC pfet_03v3 L=1u W=48u nf=1 ad='int((nf+1)/2) * W/nf * 0.18u' as='int((nf+2)/2) * W/nf * 0.18u' pd='2*int((nf+1)/2) * (W/nf + 0.18u)'
+ ps='2*int((nf+2)/2) * (W/nf + 0.18u)' nrd='0.18u / W' nrs='0.18u / W' sa=0 sb=0 sd=0 m=1
XMP3 PDA PDA VSS VSS nfet_03v3 L=1u W=16u nf=1 ad='int((nf+1)/2) * W/nf * 0.18u' as='int((nf+2)/2) * W/nf * 0.18u' pd='2*int((nf+1)/2) * (W/nf + 0.18u)'
+ ps='2*int((nf+2)/2) * (W/nf + 0.18u)' nrd='0.18u / W' nrs='0.18u / W' sa=0 sb=0 sd=0 m=1
XMP4 VDUMP PDA VSS VSS nfet_03v3 L=1u W=16u nf=1 ad='int((nf+1)/2) * W/nf * 0.18u' as='int((nf+2)/2) * W/nf * 0.18u' pd='2*int((nf+1)/2) * (W/nf + 0.18u)'
+ ps='2*int((nf+2)/2) * (W/nf + 0.18u)' nrd='0.18u / W' nrs='0.18u / W' sa=0 sb=0 sd=0 m=1
.ends

* expanding   symbol:  tgate_3v3.sym # of pins=6
** sym_path: design/tgate_3v3.sym
** sch_path: design/tgate_3v3.sch
.subckt tgate_3v3 A Y GN GP VDD VSS
*.iopin A
*.iopin Y
*.ipin GN
*.ipin GP
*.iopin VDD
*.iopin VSS
XMP Y GP A VDD pfet_03v3 L=0.28u W=2.5u nf=1 ad='int((nf+1)/2) * W/nf * 0.18u' as='int((nf+2)/2) * W/nf * 0.18u' pd='2*int((nf+1)/2) * (W/nf + 0.18u)'
+ ps='2*int((nf+2)/2) * (W/nf + 0.18u)' nrd='0.18u / W' nrs='0.18u / W' sa=0 sb=0 sd=0 m=1
XMN A GN Y VSS nfet_03v3 L=0.28u W=1u nf=1 ad='int((nf+1)/2) * W/nf * 0.18u' as='int((nf+2)/2) * W/nf * 0.18u' pd='2*int((nf+1)/2) * (W/nf + 0.18u)'
+ ps='2*int((nf+2)/2) * (W/nf + 0.18u)' nrd='0.18u / W' nrs='0.18u / W' sa=0 sb=0 sd=0 m=1
.ends

* gf180-pll :: supply-sensitivity :: supply STEP and RAMP on a locked loop
*
* DUT: `pll_top`, assembled by sim/lib/assemble_closed_loop.sh (#52) from the
* committed export of design/pll_top.sch -- the same DUT tb_supply_lock.sp
* measures, so the disturbance numbers here and the steady-state numbers there
* describe one block and not two.
*
* WHAT THIS DECK MEASURES (#14 criterion 3).  tb_supply_lock.sp answers "where
* does the loop sit at each supply"; a stepped rail has no single steady state,
* so this deck answers the other half:
*
*   - does the loop STAY locked through a fast supply step, and through a slow
*     supply ramp that crosses the whole ratified +/-10 % range;
*   - how much output-phase and output-frequency disturbance couples through
*     while it does;
*   - and does it re-settle to the same phase afterwards.
*
* The mechanism being exercised is the VCO's supply pushing, which #8 has
* already measured OPEN LOOP -- -50.7 %/V worst-case static, and -47.7 MHz/V
* transient for a 0.1 V step at the 100 MHz-class operating point
* (sim/vco-tuning-range record 20260731-184845-0a12e6c, sections 1 and 2).
* This deck deliberately does NOT re-derive that number: it measures what the
* CLOSED loop does with it.  The two are different quantities -- inside the
* loop bandwidth the PLL corrects the VCO's excursion, outside it does not --
* and conflating them is exactly the error #14 was scoped to avoid.
*
* PROFILE.  One transient carries both events, separated by enough settling
* that neither contaminates the other:
*
*   0            .. t_step     hold at v_lo (the nominal rail)
*   t_step       .. +t_edge    STEP up to v_hi          (fast: a step to a loop
*                                                        whose f_c is ~250 kHz)
*   .. t_ramp                  hold at v_hi (settle, then measure)
*   t_ramp .. t_rend           RAMP down to v_end       (slow, monotonic, spans
*                                                        the whole +/-10 % rail)
*   t_rend .. tstop            hold at v_end (settle, then measure)
*
* Expects from the generated header (sim/lib/simenv.sh):
*   .lib <corner sections>   .temp <temp_c>   .param vsup=<volts>
* `vsup` is the reference rail for every level-scaled DC input below; the
* time-varying rail is `v_lo`/`v_hi`/`v_end` and vsup is set equal to v_lo.
* From the runner, one .param each:
*   fref, nratio, vctrl0            operating point (as tb_supply_lock.sp)
*   v_lo, v_hi, v_end, t_step, t_edge, t_ramp, t_rend   the profile above
*   b*_code, cpb*_code, sel*_code, p*_code              configuration bits
*   tstop, tstep, tmax                                  transient controls
*   p1 .. p12                       phase-probe instants, each snapped by the
*                                   runner onto a reference HALF-period so the
*                                   REF and FB edges a probe pairs are the same
*                                   cycle's and cannot alias by a whole period

.param iunit=8u
.param tref='1/fref'
.param tstart='0.5*tref'

*--------------------------------------------------------------- the rail ---
* All three supply domains move together, on one PWL waveform.  They are
* separate pins on pll_top so their currents stay separable, but a block has
* one package supply and a supply-transient claim about a rail that moved only
* under the VCO would not be a claim about this block.
.param vpwl_t0=0
vvdd     vdd     0 pwl(0 'v_lo' 't_step' 'v_lo' 't_step+t_edge' 'v_hi'
+ 't_ramp' 'v_hi' 't_rend' 'v_end' 'tstop' 'v_end')
vvddvco  vdd_vco 0 pwl(0 'v_lo' 't_step' 'v_lo' 't_step+t_edge' 'v_hi'
+ 't_ramp' 'v_hi' 't_rend' 'v_end' 'tstop' 'v_end')
vvdddiv  vdd_div 0 pwl(0 'v_lo' 't_step' 'v_lo' 't_step+t_edge' 'v_hi'
+ 't_ramp' 'v_hi' 't_rend' 'v_end' 'tstop' 'v_end')
vgndvco  gnd_vco 0 dc 0
vvss     vss     0 dc 0

* Reference clock at the NOMINAL rail amplitude.  Unlike tb_supply_lock.sp --
* where the reference tracks the supply because it is a CMOS input on the same
* die -- the reference here is deliberately held at v_lo while the rail moves,
* so the measured disturbance is the loop's response to the SUPPLY and not to
* a simultaneous change in its own input amplitude.  Holding it fixed is the
* conservative choice for the input receiver's threshold: the receiver sees a
* worst-case slicing offset when the rail is high and the reference is not.
vref ref 0 pulse(0 'v_lo' 'tstart' 200p 200p '0.5*tref' 'tref')

* Static configuration bits, referenced to the NOMINAL rail.  A real static
* configuration input is driven from the same moving rail as the block, but
* these are logic levels with a rail's worth of margin either way; scaling them
* to v_lo keeps the digital levels valid at every point on the profile and
* keeps them from injecting their own (meaningless) charge step at t_step.
vb0   b0   0 dc 'v_lo*b0_code'
vb1   b1   0 dc 'v_lo*b1_code'
vb2   b2   0 dc 'v_lo*b2_code'
vcpb0 cpb0 0 dc 'v_lo*cpb0_code'
vcpb1 cpb1 0 dc 'v_lo*cpb1_code'
vp0   p0   0 dc 'v_lo*p0_code'
vp1   p1   0 dc 'v_lo*p1_code'
vp2   p2   0 dc 'v_lo*p2_code'
vp3   p3   0 dc 'v_lo*p3_code'
vp4   p4   0 dc 'v_lo*p4_code'
vp5   p5   0 dc 'v_lo*p5_code'
vs0   sel0 0 dc 'v_lo*sel0_code'
vs1   sel1 0 dc 'v_lo*sel1_code'
vs2   sel2 0 dc 'v_lo*sel2_code'
vs3   sel3 0 dc 'v_lo*sel3_code'
vs4   sel4 0 dc 'v_lo*sel4_code'
vs5   sel5 0 dc 'v_lo*sel5_code'

* Ideal charge-pump bias references, as every charge-pump campaign in this repo
* drives them.  Holding them CONSTANT through the supply excursion is the
* deliberate choice: the bias generator is a separate, unbuilt block, so any
* supply dependence assigned to it here would be invented.  The consequence is
* stated as a limitation of the record -- the disturbance reported below
* excludes whatever the real bias generator will contribute.
iibn vdd ibn dc 'iunit'
iicn vdd icn dc 'iunit'
iibp ibp 0   dc 'iunit'
iicp icp 0   dc 'iunit'

xdut ref b0 b1 b2 cpb0 cpb1 p0 p1 p2 p3 p4 p5 sel0 sel1 sel2 sel3 sel4 sel5
+ ibn icn ibp icp clk divout fb lock vctrl vdd vdd_vco gnd_vco vdd_div vss
+ pll_top

*--------------------------------------------------------- initial state ---
* Both filter nodes pre-charged -- see tb_supply_lock.sp for why setting
* VCTRL alone is not a warm start: the loop's state lives on the filter's
* series capacitor C1 (node NZ), and leaving it at 0 V turns every run into a
* cold-start acquisition ramp.
.ic v(vctrl)='vctrl0'
.ic v(xdut.xlf.nz)='vctrl0'
.ic v(xdut.xvco.y1)=0 v(xdut.xvco.y2)='v_lo' v(xdut.xvco.y3)=0
+ v(xdut.xvco.y4)='v_lo' v(xdut.xvco.y5)=0

.option rshunt=1e12 itl4=200 reltol=1e-3 abstol=1e-13 vntol=1e-6

.csparam c_tstep={tstep}
.csparam c_tstop={tstop}
.csparam c_tmax={tmax}

*------------------------------------------------------------ phase probes ---
* The static REF->FB phase error, sampled at twelve instants across the
* profile.  Phase is the right observable for this question: in a locked
* type-II loop the OUTPUT frequency is pinned to N*f_ref by construction, so a
* supply disturbance shows up first and largest as a phase excursion, and only
* as a frequency error while that excursion is being accumulated.  Reporting
* only frequency would report a disturbance as almost zero.
.meas tran phi01 trig v(ref) val='v_lo/2' rise=1 td='p1'  targ v(fb) val='v_lo/2' rise=1 td='p1'
.meas tran phi02 trig v(ref) val='v_lo/2' rise=1 td='p2'  targ v(fb) val='v_lo/2' rise=1 td='p2'
.meas tran phi03 trig v(ref) val='v_lo/2' rise=1 td='p3'  targ v(fb) val='v_lo/2' rise=1 td='p3'
.meas tran phi04 trig v(ref) val='v_lo/2' rise=1 td='p4'  targ v(fb) val='v_lo/2' rise=1 td='p4'
.meas tran phi05 trig v(ref) val='v_lo/2' rise=1 td='p5'  targ v(fb) val='v_lo/2' rise=1 td='p5'
.meas tran phi06 trig v(ref) val='v_lo/2' rise=1 td='p6'  targ v(fb) val='v_lo/2' rise=1 td='p6'
.meas tran phi07 trig v(ref) val='v_lo/2' rise=1 td='p7'  targ v(fb) val='v_lo/2' rise=1 td='p7'
.meas tran phi08 trig v(ref) val='v_lo/2' rise=1 td='p8'  targ v(fb) val='v_lo/2' rise=1 td='p8'
.meas tran phi09 trig v(ref) val='v_lo/2' rise=1 td='p9'  targ v(fb) val='v_lo/2' rise=1 td='p9'
.meas tran phi10 trig v(ref) val='v_lo/2' rise=1 td='p10' targ v(fb) val='v_lo/2' rise=1 td='p10'
.meas tran phi11 trig v(ref) val='v_lo/2' rise=1 td='p11' targ v(fb) val='v_lo/2' rise=1 td='p11'
.meas tran phi12 trig v(ref) val='v_lo/2' rise=1 td='p12' targ v(fb) val='v_lo/2' rise=1 td='p12'

* Residual frequency error in the three SETTLED plateaus, each measured the
* same way tb_supply_lock.sp measures it: the drift of the static phase
* between two instants.  If any of these is not small the loop is not locked
* on that plateau, whatever the LOCK flag says.
.meas tran ferr_lo  param='-(phi02-phi01)/(p2-p1)'
.meas tran ferr_hi  param='-(phi08-phi07)/(p8-p7)'
.meas tran ferr_end param='-(phi12-phi11)/(p12-p11)'

*--------------------------------------------------------------- frequency ---
* Output frequency on each settled plateau, over 100 whole CLK cycles.
.meas tran tclk_lo  trig v(clk) val='v_lo/2' rise=1 td='p1'  targ v(clk) val='v_lo/2' rise=101 td='p1'
.meas tran fout_lo  param='100/tclk_lo'
.meas tran tclk_hi  trig v(clk) val='v_hi/2' rise=1 td='p7'  targ v(clk) val='v_hi/2' rise=101 td='p7'
.meas tran fout_hi  param='100/tclk_hi'
.meas tran tclk_end trig v(clk) val='v_end/2' rise=1 td='p11' targ v(clk) val='v_end/2' rise=101 td='p11'
.meas tran fout_end param='100/tclk_end'

* The output frequency during the two DISTURBANCES, over a short cycle count so
* the window is inside the excursion rather than averaging across it.  20 CLK
* cycles is 200 ns at 100 MHz, i.e. ~1/20 of the loop's own response time.
.meas tran tclk_s trig v(clk) val='v_hi/2' rise=1 td='t_step+t_edge' targ v(clk) val='v_hi/2' rise=21 td='t_step+t_edge'
.meas tran fout_s param='20/tclk_s'
.meas tran tclk_r trig v(clk) val='v_hi/2' rise=1 td='p9' targ v(clk) val='v_hi/2' rise=21 td='p9'
.meas tran fout_r param='20/tclk_r'

*------------------------------------------------------------ control node ---
* Vctrl is where the loop's correction of the supply excursion is visible: the
* loop holds f_out at N*f_ref by moving Vctrl against the VCO's supply
* pushing, so d(Vctrl) across the profile IS the pushing the loop absorbed.
.meas tran vc_lo   avg v(vctrl) from='p1' to='p2'
.meas tran vc_hi   avg v(vctrl) from='p7' to='p8'
.meas tran vc_end  avg v(vctrl) from='p11' to='p12'
.meas tran vc_smax max v(vctrl) from='t_step' to='p6'
.meas tran vc_smin min v(vctrl) from='t_step' to='p6'
.meas tran vc_rmax max v(vctrl) from='t_ramp' to='t_rend'
.meas tran vc_rmin min v(vctrl) from='t_ramp' to='t_rend'
.meas tran vc_all_max max v(vctrl) from='p1' to='tstop'
.meas tran vc_all_min min v(vctrl) from='p1' to='tstop'

*------------------------------------------------------------- LOCK flag -----
* #11's window comparator, averaged over each phase of the profile.  A flag
* that drops out during the step or the ramp and comes back is the honest
* signature of "lost lock and re-acquired", and it reads here as an average
* below the rail rather than being rounded to a verdict.
.meas tran lock_lo   avg v(lock) from='p1' to='p2'
.meas tran lock_stp  avg v(lock) from='t_step' to='p6'
.meas tran lock_hi   avg v(lock) from='p7' to='p8'
.meas tran lock_rmp  avg v(lock) from='t_ramp' to='t_rend'
.meas tran lock_end  avg v(lock) from='p11' to='p12'
.meas tran lock_min  min v(lock) from='p1' to='tstop'

*-------------------------------------------------------------------- power ---
* Per-domain current on each settled plateau, so the power reported by
* tb_supply_lock.sp at 2.97 / 3.30 / 3.63 V has an independent cross-check
* taken on a rail that ARRIVED at those voltages rather than starting there.
.meas tran i_core_lo  avg i(vvdd)    from='p1' to='p2'
.meas tran i_vco_lo   avg i(vvddvco) from='p1' to='p2'
.meas tran i_div_lo   avg i(vvdddiv) from='p1' to='p2'
.meas tran i_core_hi  avg i(vvdd)    from='p7' to='p8'
.meas tran i_vco_hi   avg i(vvddvco) from='p7' to='p8'
.meas tran i_div_hi   avg i(vvdddiv) from='p7' to='p8'
.meas tran i_core_end avg i(vvdd)    from='p11' to='p12'
.meas tran i_vco_end  avg i(vvddvco) from='p11' to='p12'
.meas tran i_div_end  avg i(vvdddiv) from='p11' to='p12'

*---------------------------------------------------------------- transient ---
* The disturbance transient IS the evidence for this criterion, so the trace is
* retained -- as a CSV of the four signals that carry the argument, decimated
* by the runner, never as a rawfile (sim/README.md's waveform rule).
.control
  set noaskquit
  tran $&c_tstep $&c_tstop 0 $&c_tmax
  wrdata supply_transient_full.csv v(vctrl) v(lock) v(vdd) v(fb)
.endc
