* Extracted by KLayout with GF180MCU LVS runset on : 09/09/2026 01:18

.SUBCKT nand2_3v3 VSS B A Y VDD
M$1 VDD B Y VDD pfet_03v3 L=0.28U W=2.5U AS=1.25P AD=1.25P PS=6U PD=6U
M$2 VDD A Y VDD pfet_03v3 L=0.28U W=2.5U AS=1.25P AD=1.25P PS=6U PD=6U
M$3 Y A \$4 VSS nfet_03v3 L=0.28U W=2U AS=1P AD=1P PS=5U PD=5U
M$4 \$4 B VSS VSS nfet_03v3 L=0.28U W=2U AS=1P AD=1P PS=5U PD=5U
.ENDS nand2_3v3
