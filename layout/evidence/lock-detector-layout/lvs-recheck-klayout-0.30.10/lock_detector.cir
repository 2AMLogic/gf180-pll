* Extracted by KLayout with GF180MCU LVS runset on : 21/09/2026 23:20

.SUBCKT lock_detector DN ERR ERRD LDT0 LDT1 LDT2 LDT3 LOCK LOCKB UP VDD VSS
+ VWIN WIDE WIDEB XDLY_D1 XDLY_D2 XDLY_D3 XDLY_S10 XDLY_S11 XDLY_S12 XDLY_S13
+ XDLY_S20 XDLY_S21 XDLY_S22 XDLY_S23 XDLY_S30 XDLY_S31 XDLY_S32 XDLY_S33
+ XDLY_S40 XDLY_S41 XDLY_S42 XDLY_S43 XDLY_T0B XDLY_T1B XDLY_T2B XDLY_T3B
+ XERR_G1_NMID XERR_G2_NMID XERR_G3_NMID XERR_G4_NMID XERR_N1 XERR_N2 XERR_N3
+ XNW_NMID XSCH_N1 XSCH_P1
M$1 XERR_N1 UP VDD VDD pfet_03v3 L=0.28U W=2.5U AS=2.5P AD=2.5P PS=7U PD=7U
M$2 XERR_N1 DN VDD VDD pfet_03v3 L=0.28U W=2.5U AS=2.5P AD=2.5P PS=7U PD=7U
M$3 XERR_N2 UP VDD VDD pfet_03v3 L=0.28U W=2.5U AS=2.5P AD=2.5P PS=7U PD=7U
M$4 XERR_N2 XERR_N1 VDD VDD pfet_03v3 L=0.28U W=2.5U AS=2.5P AD=2.5P PS=7U PD=7U
M$5 XERR_N3 DN VDD VDD pfet_03v3 L=0.28U W=2.5U AS=2.5P AD=2.5P PS=7U PD=7U
M$6 XERR_N3 XERR_N1 VDD VDD pfet_03v3 L=0.28U W=2.5U AS=2.5P AD=2.5P PS=7U PD=7U
M$7 ERR XERR_N2 VDD VDD pfet_03v3 L=0.28U W=2.5U AS=2.5P AD=2.5P PS=7U PD=7U
M$8 ERR XERR_N3 VDD VDD pfet_03v3 L=0.28U W=2.5U AS=2.5P AD=2.5P PS=7U PD=7U
M$9 XDLY_T0B LDT0 VDD VDD pfet_03v3 L=0.28U W=2.5U AS=2.5P AD=2.5P PS=7U PD=7U
M$10 XDLY_T1B LDT1 VDD VDD pfet_03v3 L=0.28U W=2.5U AS=2.5P AD=2.5P PS=7U PD=7U
M$11 XDLY_T2B LDT2 VDD VDD pfet_03v3 L=0.28U W=2.5U AS=2.5P AD=2.5P PS=7U PD=7U
M$12 XDLY_T3B LDT3 VDD VDD pfet_03v3 L=0.28U W=2.5U AS=2.5P AD=2.5P PS=7U PD=7U
M$13 XDLY_D1 ERR VDD VDD pfet_03v3 L=0.28U W=2.5U AS=2.5P AD=2.5P PS=7U PD=7U
M$14 XDLY_D2 XDLY_D1 VDD VDD pfet_03v3 L=0.28U W=2.5U AS=2.5P AD=2.5P PS=7U
+ PD=7U
M$15 XDLY_D3 XDLY_D2 VDD VDD pfet_03v3 L=0.28U W=2.5U AS=2.5P AD=2.5P PS=7U
+ PD=7U
M$16 ERRD XDLY_D3 VDD VDD pfet_03v3 L=0.28U W=2.5U AS=2.5P AD=2.5P PS=7U PD=7U
M$17 WIDEB ERR VDD VDD pfet_03v3 L=0.28U W=2.5U AS=2.5P AD=2.5P PS=7U PD=7U
M$18 WIDEB ERRD VDD VDD pfet_03v3 L=0.28U W=2.5U AS=2.5P AD=2.5P PS=7U PD=7U
M$19 WIDE WIDEB VDD VDD pfet_03v3 L=0.28U W=2.5U AS=2.5P AD=2.5P PS=7U PD=7U
M$20 XSCH_P1 VWIN VDD VDD pfet_03v3 L=0.28U W=2.5U AS=2.5P AD=2.5P PS=7U PD=7U
M$21 LOCKB VWIN XSCH_P1 VDD pfet_03v3 L=0.28U W=2.5U AS=2.5P AD=2.5P PS=7U PD=7U
M$22 LOCK LOCKB VDD VDD pfet_03v3 L=0.28U W=2.5U AS=2.5P AD=2.5P PS=7U PD=7U
M$23 XDLY_S10 XDLY_T0B XDLY_D1 VDD pfet_03v3 L=0.28U W=0.22U AS=0.43P AD=0.43P
+ PS=3U PD=3U
M$24 XDLY_S11 XDLY_T1B XDLY_D1 VDD pfet_03v3 L=0.28U W=0.44U AS=0.44P AD=0.44P
+ PS=2.88U PD=2.88U
M$25 XDLY_S12 XDLY_T2B XDLY_D1 VDD pfet_03v3 L=0.28U W=0.88U AS=0.88P AD=0.88P
+ PS=3.76U PD=3.76U
M$26 XDLY_S13 XDLY_T3B XDLY_D1 VDD pfet_03v3 L=0.28U W=1.76U AS=1.76P AD=1.76P
+ PS=5.52U PD=5.52U
M$27 XDLY_S20 XDLY_T0B XDLY_D2 VDD pfet_03v3 L=0.28U W=0.22U AS=0.43P AD=0.43P
+ PS=3U PD=3U
M$28 XDLY_S21 XDLY_T1B XDLY_D2 VDD pfet_03v3 L=0.28U W=0.44U AS=0.44P AD=0.44P
+ PS=2.88U PD=2.88U
M$29 XDLY_S22 XDLY_T2B XDLY_D2 VDD pfet_03v3 L=0.28U W=0.88U AS=0.88P AD=0.88P
+ PS=3.76U PD=3.76U
M$30 XDLY_S23 XDLY_T3B XDLY_D2 VDD pfet_03v3 L=0.28U W=1.76U AS=1.76P AD=1.76P
+ PS=5.52U PD=5.52U
M$31 XDLY_S30 XDLY_T0B XDLY_D3 VDD pfet_03v3 L=0.28U W=0.22U AS=0.43P AD=0.43P
+ PS=3U PD=3U
M$32 XDLY_S31 XDLY_T1B XDLY_D3 VDD pfet_03v3 L=0.28U W=0.44U AS=0.44P AD=0.44P
+ PS=2.88U PD=2.88U
M$33 XDLY_S32 XDLY_T2B XDLY_D3 VDD pfet_03v3 L=0.28U W=0.88U AS=0.88P AD=0.88P
+ PS=3.76U PD=3.76U
M$34 XDLY_S33 XDLY_T3B XDLY_D3 VDD pfet_03v3 L=0.28U W=1.76U AS=1.76P AD=1.76P
+ PS=5.52U PD=5.52U
M$35 XDLY_S40 XDLY_T0B ERRD VDD pfet_03v3 L=0.28U W=0.22U AS=0.43P AD=0.43P
+ PS=3U PD=3U
M$36 XDLY_S41 XDLY_T1B ERRD VDD pfet_03v3 L=0.28U W=0.44U AS=0.44P AD=0.44P
+ PS=2.88U PD=2.88U
M$37 XDLY_S42 XDLY_T2B ERRD VDD pfet_03v3 L=0.28U W=0.88U AS=0.88P AD=0.88P
+ PS=3.76U PD=3.76U
M$38 XDLY_S43 XDLY_T3B ERRD VDD pfet_03v3 L=0.28U W=1.76U AS=1.76P AD=1.76P
+ PS=5.52U PD=5.52U
M$39 VWIN VSS VDD VDD pfet_03v3 L=20U W=0.22U AS=0.43P AD=0.43P PS=3U PD=3U
M$40 VSS LOCKB XSCH_P1 VDD pfet_03v3 L=0.28U W=1.2U AS=1.2P AD=1.2P PS=4.4U
+ PD=4.4U
M$41 XERR_N1 UP XERR_G1_NMID VSS nfet_03v3 L=0.28U W=2U AS=2P AD=2P PS=6U PD=6U
M$42 XERR_G1_NMID DN VSS VSS nfet_03v3 L=0.28U W=2U AS=2P AD=2P PS=6U PD=6U
M$43 XERR_N2 UP XERR_G2_NMID VSS nfet_03v3 L=0.28U W=2U AS=2P AD=2P PS=6U PD=6U
M$44 XERR_G2_NMID XERR_N1 VSS VSS nfet_03v3 L=0.28U W=2U AS=2P AD=2P PS=6U PD=6U
M$45 XERR_N3 DN XERR_G3_NMID VSS nfet_03v3 L=0.28U W=2U AS=2P AD=2P PS=6U PD=6U
M$46 XERR_G3_NMID XERR_N1 VSS VSS nfet_03v3 L=0.28U W=2U AS=2P AD=2P PS=6U PD=6U
M$47 ERR XERR_N2 XERR_G4_NMID VSS nfet_03v3 L=0.28U W=2U AS=2P AD=2P PS=6U PD=6U
M$48 XERR_G4_NMID XERR_N3 VSS VSS nfet_03v3 L=0.28U W=2U AS=2P AD=2P PS=6U PD=6U
M$49 WIDEB ERR XNW_NMID VSS nfet_03v3 L=0.28U W=2U AS=2P AD=2P PS=6U PD=6U
M$50 XNW_NMID ERRD VSS VSS nfet_03v3 L=0.28U W=2U AS=2P AD=2P PS=6U PD=6U
M$51 VWIN WIDE VSS VSS nfet_03v3 L=0.5U W=2U AS=2P AD=2P PS=6U PD=6U
M$52 XDLY_T0B LDT0 VSS VSS nfet_03v3 L=0.28U W=1U AS=1P AD=1P PS=4U PD=4U
M$53 XDLY_T1B LDT1 VSS VSS nfet_03v3 L=0.28U W=1U AS=1P AD=1P PS=4U PD=4U
M$54 XDLY_T2B LDT2 VSS VSS nfet_03v3 L=0.28U W=1U AS=1P AD=1P PS=4U PD=4U
M$55 XDLY_T3B LDT3 VSS VSS nfet_03v3 L=0.28U W=1U AS=1P AD=1P PS=4U PD=4U
M$56 XDLY_D1 ERR VSS VSS nfet_03v3 L=0.28U W=1U AS=1P AD=1P PS=4U PD=4U
M$57 XDLY_D1 LDT3 XDLY_S13 VSS nfet_03v3 L=0.28U W=1.76U AS=1.76P AD=1.76P
+ PS=5.52U PD=5.52U
M$58 XDLY_S13 XDLY_T3B VSS VSS nfet_03v3 L=0.5U W=1.76U AS=1.76P AD=1.76P
+ PS=5.52U PD=5.52U
M$59 XDLY_D2 XDLY_D1 VSS VSS nfet_03v3 L=0.28U W=1U AS=1P AD=1P PS=4U PD=4U
M$60 XDLY_D2 LDT3 XDLY_S23 VSS nfet_03v3 L=0.28U W=1.76U AS=1.76P AD=1.76P
+ PS=5.52U PD=5.52U
M$61 XDLY_S23 XDLY_T3B VSS VSS nfet_03v3 L=0.5U W=1.76U AS=1.76P AD=1.76P
+ PS=5.52U PD=5.52U
M$62 XDLY_D3 XDLY_D2 VSS VSS nfet_03v3 L=0.28U W=1U AS=1P AD=1P PS=4U PD=4U
M$63 XDLY_D3 LDT3 XDLY_S33 VSS nfet_03v3 L=0.28U W=1.76U AS=1.76P AD=1.76P
+ PS=5.52U PD=5.52U
M$64 XDLY_S33 XDLY_T3B VSS VSS nfet_03v3 L=0.5U W=1.76U AS=1.76P AD=1.76P
+ PS=5.52U PD=5.52U
M$65 ERRD XDLY_D3 VSS VSS nfet_03v3 L=0.28U W=1U AS=1P AD=1P PS=4U PD=4U
M$66 ERRD LDT3 XDLY_S43 VSS nfet_03v3 L=0.28U W=1.76U AS=1.76P AD=1.76P
+ PS=5.52U PD=5.52U
M$67 XDLY_S43 XDLY_T3B VSS VSS nfet_03v3 L=0.5U W=1.76U AS=1.76P AD=1.76P
+ PS=5.52U PD=5.52U
M$68 WIDE WIDEB VSS VSS nfet_03v3 L=0.28U W=1U AS=1P AD=1P PS=4U PD=4U
M$69 XSCH_N1 VWIN VSS VSS nfet_03v3 L=0.28U W=1U AS=1P AD=1P PS=4U PD=4U
M$70 LOCKB VWIN XSCH_N1 VSS nfet_03v3 L=0.28U W=1U AS=1P AD=1P PS=4U PD=4U
M$71 LOCK LOCKB VSS VSS nfet_03v3 L=0.28U W=1U AS=1P AD=1P PS=4U PD=4U
M$72 VSS XDLY_D1 VSS VSS nfet_03v3 L=2U W=6.2U AS=6.2P AD=6.2P PS=14.4U PD=14.4U
M$73 XDLY_D1 LDT0 XDLY_S10 VSS nfet_03v3 L=0.28U W=0.22U AS=0.43P AD=0.43P
+ PS=3U PD=3U
M$74 XDLY_S10 XDLY_T0B VSS VSS nfet_03v3 L=0.5U W=0.22U AS=0.43P AD=0.43P PS=3U
+ PD=3U
M$75 XDLY_D1 LDT1 XDLY_S11 VSS nfet_03v3 L=0.28U W=0.44U AS=0.44P AD=0.44P
+ PS=2.88U PD=2.88U
M$76 XDLY_S11 XDLY_T1B VSS VSS nfet_03v3 L=0.5U W=0.44U AS=0.44P AD=0.44P
+ PS=2.88U PD=2.88U
M$77 XDLY_D1 LDT2 XDLY_S12 VSS nfet_03v3 L=0.28U W=0.88U AS=0.88P AD=0.88P
+ PS=3.76U PD=3.76U
M$78 XDLY_S12 XDLY_T2B VSS VSS nfet_03v3 L=0.5U W=0.88U AS=0.88P AD=0.88P
+ PS=3.76U PD=3.76U
M$79 VSS XDLY_S13 VSS VSS nfet_03v3 L=1U W=4U AS=4P AD=4P PS=10U PD=10U
M$80 VSS XDLY_D2 VSS VSS nfet_03v3 L=2U W=6.2U AS=6.2P AD=6.2P PS=14.4U PD=14.4U
M$81 XDLY_D2 LDT0 XDLY_S20 VSS nfet_03v3 L=0.28U W=0.22U AS=0.43P AD=0.43P
+ PS=3U PD=3U
M$82 XDLY_S20 XDLY_T0B VSS VSS nfet_03v3 L=0.5U W=0.22U AS=0.43P AD=0.43P PS=3U
+ PD=3U
M$83 XDLY_D2 LDT1 XDLY_S21 VSS nfet_03v3 L=0.28U W=0.44U AS=0.44P AD=0.44P
+ PS=2.88U PD=2.88U
M$84 XDLY_S21 XDLY_T1B VSS VSS nfet_03v3 L=0.5U W=0.44U AS=0.44P AD=0.44P
+ PS=2.88U PD=2.88U
M$85 XDLY_D2 LDT2 XDLY_S22 VSS nfet_03v3 L=0.28U W=0.88U AS=0.88P AD=0.88P
+ PS=3.76U PD=3.76U
M$86 XDLY_S22 XDLY_T2B VSS VSS nfet_03v3 L=0.5U W=0.88U AS=0.88P AD=0.88P
+ PS=3.76U PD=3.76U
M$87 VSS XDLY_S23 VSS VSS nfet_03v3 L=1U W=4U AS=4P AD=4P PS=10U PD=10U
M$88 VSS XDLY_D3 VSS VSS nfet_03v3 L=2U W=6.2U AS=6.2P AD=6.2P PS=14.4U PD=14.4U
M$89 XDLY_D3 LDT0 XDLY_S30 VSS nfet_03v3 L=0.28U W=0.22U AS=0.43P AD=0.43P
+ PS=3U PD=3U
M$90 XDLY_S30 XDLY_T0B VSS VSS nfet_03v3 L=0.5U W=0.22U AS=0.43P AD=0.43P PS=3U
+ PD=3U
M$91 XDLY_D3 LDT1 XDLY_S31 VSS nfet_03v3 L=0.28U W=0.44U AS=0.44P AD=0.44P
+ PS=2.88U PD=2.88U
M$92 XDLY_S31 XDLY_T1B VSS VSS nfet_03v3 L=0.5U W=0.44U AS=0.44P AD=0.44P
+ PS=2.88U PD=2.88U
M$93 XDLY_D3 LDT2 XDLY_S32 VSS nfet_03v3 L=0.28U W=0.88U AS=0.88P AD=0.88P
+ PS=3.76U PD=3.76U
M$94 XDLY_S32 XDLY_T2B VSS VSS nfet_03v3 L=0.5U W=0.88U AS=0.88P AD=0.88P
+ PS=3.76U PD=3.76U
M$95 VSS XDLY_S33 VSS VSS nfet_03v3 L=1U W=4U AS=4P AD=4P PS=10U PD=10U
M$96 VSS ERRD VSS VSS nfet_03v3 L=2U W=6.2U AS=6.2P AD=6.2P PS=14.4U PD=14.4U
M$97 ERRD LDT0 XDLY_S40 VSS nfet_03v3 L=0.28U W=0.22U AS=0.43P AD=0.43P PS=3U
+ PD=3U
M$98 XDLY_S40 XDLY_T0B VSS VSS nfet_03v3 L=0.5U W=0.22U AS=0.43P AD=0.43P PS=3U
+ PD=3U
M$99 ERRD LDT1 XDLY_S41 VSS nfet_03v3 L=0.28U W=0.44U AS=0.44P AD=0.44P
+ PS=2.88U PD=2.88U
M$100 XDLY_S41 XDLY_T1B VSS VSS nfet_03v3 L=0.5U W=0.44U AS=0.44P AD=0.44P
+ PS=2.88U PD=2.88U
M$101 ERRD LDT2 XDLY_S42 VSS nfet_03v3 L=0.28U W=0.88U AS=0.88P AD=0.88P
+ PS=3.76U PD=3.76U
M$102 XDLY_S42 XDLY_T2B VSS VSS nfet_03v3 L=0.5U W=0.88U AS=0.88P AD=0.88P
+ PS=3.76U PD=3.76U
M$103 VSS XDLY_S43 VSS VSS nfet_03v3 L=1U W=4U AS=4P AD=4P PS=10U PD=10U
M$104 VDD LOCKB XSCH_N1 VSS nfet_03v3 L=0.28U W=0.5U AS=0.5P AD=0.5P PS=3U PD=3U
M$105 VSS XDLY_S11 VSS VSS nfet_03v3 L=1U W=1U AS=1P AD=1P PS=4U PD=4U
M$106 VSS XDLY_S12 VSS VSS nfet_03v3 L=1U W=2U AS=2P AD=2P PS=6U PD=6U
M$107 VSS XDLY_S21 VSS VSS nfet_03v3 L=1U W=1U AS=1P AD=1P PS=4U PD=4U
M$108 VSS XDLY_S22 VSS VSS nfet_03v3 L=1U W=2U AS=2P AD=2P PS=6U PD=6U
M$109 VSS XDLY_S31 VSS VSS nfet_03v3 L=1U W=1U AS=1P AD=1P PS=4U PD=4U
M$110 VSS XDLY_S32 VSS VSS nfet_03v3 L=1U W=2U AS=2P AD=2P PS=6U PD=6U
M$111 VSS XDLY_S41 VSS VSS nfet_03v3 L=1U W=1U AS=1P AD=1P PS=4U PD=4U
M$112 VSS XDLY_S42 VSS VSS nfet_03v3 L=1U W=2U AS=2P AD=2P PS=6U PD=6U
M$113 VSS XDLY_S10 VSS VSS nfet_03v3 L=1U W=0.5U AS=0.5P AD=0.5P PS=3U PD=3U
M$114 VSS XDLY_S20 VSS VSS nfet_03v3 L=1U W=0.5U AS=0.5P AD=0.5P PS=3U PD=3U
M$115 VSS XDLY_S30 VSS VSS nfet_03v3 L=1U W=0.5U AS=0.5P AD=0.5P PS=3U PD=3U
M$116 VSS XDLY_S40 VSS VSS nfet_03v3 L=1U W=0.5U AS=0.5P AD=0.5P PS=3U PD=3U
M$117 VSS VWIN VSS VSS nfet_03v3 L=6U W=30U AS=30P AD=30P PS=62U PD=62U
.ENDS lock_detector
