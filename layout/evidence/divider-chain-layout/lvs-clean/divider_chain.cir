* Extracted by KLayout with GF180MCU LVS runset on : 09/09/2026 04:35

.SUBCKT divider_chain VSS MO0|MODOUT CKIN|VCO MO1|MODOUT CK1|CKIN|CKOUT
+ MO2|MODOUT CK2|CKIN|CKOUT MO3|MODOUT CK3|CKIN|CKOUT MO4|MODOUT CK4|CKIN|CKOUT
+ MO5|MODOUT CK5|CKIN|CKOUT MI0|MODIN P|P0 VDD|VDD_DIV MI1|MODIN P|P1 MI2|MODIN
+ P|P2 MI3|MODIN P|P3 MI4|MODIN P|P4 MODIN|SEL5 P|P5 CK6|CKOUT NMI0 NMI1 NMI2
+ NMI3 NMI4 XM0_NMID T0 T1 XM1_NMID T2 XM2_NMID T3 XM3_NMID T4 XM4_NMID
+ XM5_NMID T5 XMA_NM2 XMA_NM1 MA XMB_NM2 XMB_NM1 MB DIVOUTB DIVOUT XFRT_CKB
+ XFRT_CKBB XFRT_NM XFRT_NMA XFRT_NMB XFRT_NS FB FBB SEL0 SEL1 SEL2 SEL3 SEL4
+ XNR0_PMID XNR1_PMID XNR2_PMID XNR3_PMID XNR4_PMID XMNO_PMID
M$1 VDD|VDD_DIV MI0|MODIN \$18 VDD|VDD_DIV pfet_03v3 L=0.28U W=2.5U AS=1.25P
+ AD=1.25P PS=6U PD=6U
M$2 VDD|VDD_DIV P|P0 \$18 VDD|VDD_DIV pfet_03v3 L=0.28U W=2.5U AS=1.25P
+ AD=1.25P PS=6U PD=6U
M$3 VDD|VDD_DIV MO0|MODOUT \$18 VDD|VDD_DIV pfet_03v3 L=0.28U W=2.5U AS=1.25P
+ AD=1.25P PS=6U PD=6U
M$4 VDD|VDD_DIV \$20 \$21 VDD|VDD_DIV pfet_03v3 L=0.28U W=2.5U AS=1.25P
+ AD=1.25P PS=6U PD=6U
M$5 VDD|VDD_DIV \$18 \$21 VDD|VDD_DIV pfet_03v3 L=0.28U W=2.5U AS=1.25P
+ AD=1.25P PS=6U PD=6U
M$6 VDD|VDD_DIV \$21 \$23 VDD|VDD_DIV pfet_03v3 L=0.28U W=2.5U AS=1.25P
+ AD=1.25P PS=6U PD=6U
M$7 VDD|VDD_DIV CKIN|VCO \$24 VDD|VDD_DIV pfet_03v3 L=0.28U W=2.5U AS=1.25P
+ AD=1.25P PS=6U PD=6U
M$8 VDD|VDD_DIV \$24 \$25 VDD|VDD_DIV pfet_03v3 L=0.28U W=2.5U AS=1.25P
+ AD=1.25P PS=6U PD=6U
M$9 \$23 \$25 \$26 VDD|VDD_DIV pfet_03v3 L=0.28U W=2.5U AS=1.25P AD=1.25P PS=6U
+ PD=6U
M$10 VDD|VDD_DIV \$26 \$27 VDD|VDD_DIV pfet_03v3 L=0.28U W=2.5U AS=1.25P
+ AD=1.25P PS=6U PD=6U
M$11 VDD|VDD_DIV \$27 \$28 VDD|VDD_DIV pfet_03v3 L=0.28U W=2.5U AS=1.25P
+ AD=1.25P PS=6U PD=6U
M$12 \$28 \$24 \$26 VDD|VDD_DIV pfet_03v3 L=0.28U W=2.5U AS=1.25P AD=1.25P
+ PS=6U PD=6U
M$13 \$27 \$24 \$29 VDD|VDD_DIV pfet_03v3 L=0.28U W=2.5U AS=1.25P AD=1.25P
+ PS=6U PD=6U
M$14 VDD|VDD_DIV \$29 \$30 VDD|VDD_DIV pfet_03v3 L=0.28U W=2.5U AS=1.25P
+ AD=1.25P PS=6U PD=6U
M$15 VDD|VDD_DIV \$30 \$20 VDD|VDD_DIV pfet_03v3 L=0.28U W=2.5U AS=1.25P
+ AD=1.25P PS=6U PD=6U
M$16 \$20 \$25 \$29 VDD|VDD_DIV pfet_03v3 L=0.28U W=2.5U AS=1.25P AD=1.25P
+ PS=6U PD=6U
M$17 VDD|VDD_DIV \$20 CK1|CKIN|CKOUT VDD|VDD_DIV pfet_03v3 L=0.28U W=5U AS=2.5P
+ AD=2.5P PS=11U PD=11U
M$18 VDD|VDD_DIV MI0|MODIN \$31 VDD|VDD_DIV pfet_03v3 L=0.28U W=2.5U AS=1.25P
+ AD=1.25P PS=6U PD=6U
M$19 VDD|VDD_DIV \$30 \$31 VDD|VDD_DIV pfet_03v3 L=0.28U W=2.5U AS=1.25P
+ AD=1.25P PS=6U PD=6U
M$20 VDD|VDD_DIV \$31 \$33 VDD|VDD_DIV pfet_03v3 L=0.28U W=2.5U AS=1.25P
+ AD=1.25P PS=6U PD=6U
M$21 VDD|VDD_DIV CKIN|VCO \$34 VDD|VDD_DIV pfet_03v3 L=0.28U W=2.5U AS=1.25P
+ AD=1.25P PS=6U PD=6U
M$22 VDD|VDD_DIV \$34 \$35 VDD|VDD_DIV pfet_03v3 L=0.28U W=2.5U AS=1.25P
+ AD=1.25P PS=6U PD=6U
M$23 \$33 \$35 \$36 VDD|VDD_DIV pfet_03v3 L=0.28U W=2.5U AS=1.25P AD=1.25P
+ PS=6U PD=6U
M$24 VDD|VDD_DIV \$36 \$37 VDD|VDD_DIV pfet_03v3 L=0.28U W=2.5U AS=1.25P
+ AD=1.25P PS=6U PD=6U
M$25 VDD|VDD_DIV \$37 \$38 VDD|VDD_DIV pfet_03v3 L=0.28U W=2.5U AS=1.25P
+ AD=1.25P PS=6U PD=6U
M$26 \$38 \$34 \$36 VDD|VDD_DIV pfet_03v3 L=0.28U W=2.5U AS=1.25P AD=1.25P
+ PS=6U PD=6U
M$27 \$37 \$34 \$39 VDD|VDD_DIV pfet_03v3 L=0.28U W=2.5U AS=1.25P AD=1.25P
+ PS=6U PD=6U
M$28 VDD|VDD_DIV \$39 MO0|MODOUT VDD|VDD_DIV pfet_03v3 L=0.28U W=2.5U AS=1.25P
+ AD=1.25P PS=6U PD=6U
M$29 VDD|VDD_DIV MO0|MODOUT \$40 VDD|VDD_DIV pfet_03v3 L=0.28U W=2.5U AS=1.25P
+ AD=1.25P PS=6U PD=6U
M$30 \$40 \$35 \$39 VDD|VDD_DIV pfet_03v3 L=0.28U W=2.5U AS=1.25P AD=1.25P
+ PS=6U PD=6U
M$31 VDD|VDD_DIV MI1|MODIN \$45 VDD|VDD_DIV pfet_03v3 L=0.28U W=2.5U AS=1.25P
+ AD=1.25P PS=6U PD=6U
M$32 VDD|VDD_DIV P|P1 \$45 VDD|VDD_DIV pfet_03v3 L=0.28U W=2.5U AS=1.25P
+ AD=1.25P PS=6U PD=6U
M$33 VDD|VDD_DIV MO1|MODOUT \$45 VDD|VDD_DIV pfet_03v3 L=0.28U W=2.5U AS=1.25P
+ AD=1.25P PS=6U PD=6U
M$34 VDD|VDD_DIV \$46 \$48 VDD|VDD_DIV pfet_03v3 L=0.28U W=2.5U AS=1.25P
+ AD=1.25P PS=6U PD=6U
M$35 VDD|VDD_DIV \$45 \$48 VDD|VDD_DIV pfet_03v3 L=0.28U W=2.5U AS=1.25P
+ AD=1.25P PS=6U PD=6U
M$36 VDD|VDD_DIV \$48 \$49 VDD|VDD_DIV pfet_03v3 L=0.28U W=2.5U AS=1.25P
+ AD=1.25P PS=6U PD=6U
M$37 VDD|VDD_DIV CK1|CKIN|CKOUT \$50 VDD|VDD_DIV pfet_03v3 L=0.28U W=2.5U
+ AS=1.25P AD=1.25P PS=6U PD=6U
M$38 VDD|VDD_DIV \$50 \$51 VDD|VDD_DIV pfet_03v3 L=0.28U W=2.5U AS=1.25P
+ AD=1.25P PS=6U PD=6U
M$39 \$49 \$51 \$52 VDD|VDD_DIV pfet_03v3 L=0.28U W=2.5U AS=1.25P AD=1.25P
+ PS=6U PD=6U
M$40 VDD|VDD_DIV \$52 \$53 VDD|VDD_DIV pfet_03v3 L=0.28U W=2.5U AS=1.25P
+ AD=1.25P PS=6U PD=6U
M$41 VDD|VDD_DIV \$53 \$54 VDD|VDD_DIV pfet_03v3 L=0.28U W=2.5U AS=1.25P
+ AD=1.25P PS=6U PD=6U
M$42 \$54 \$50 \$52 VDD|VDD_DIV pfet_03v3 L=0.28U W=2.5U AS=1.25P AD=1.25P
+ PS=6U PD=6U
M$43 \$53 \$50 \$55 VDD|VDD_DIV pfet_03v3 L=0.28U W=2.5U AS=1.25P AD=1.25P
+ PS=6U PD=6U
M$44 VDD|VDD_DIV \$55 \$56 VDD|VDD_DIV pfet_03v3 L=0.28U W=2.5U AS=1.25P
+ AD=1.25P PS=6U PD=6U
M$45 VDD|VDD_DIV \$56 \$46 VDD|VDD_DIV pfet_03v3 L=0.28U W=2.5U AS=1.25P
+ AD=1.25P PS=6U PD=6U
M$46 \$46 \$51 \$55 VDD|VDD_DIV pfet_03v3 L=0.28U W=2.5U AS=1.25P AD=1.25P
+ PS=6U PD=6U
M$47 VDD|VDD_DIV \$46 CK2|CKIN|CKOUT VDD|VDD_DIV pfet_03v3 L=0.28U W=5U AS=2.5P
+ AD=2.5P PS=11U PD=11U
M$48 VDD|VDD_DIV MI1|MODIN \$58 VDD|VDD_DIV pfet_03v3 L=0.28U W=2.5U AS=1.25P
+ AD=1.25P PS=6U PD=6U
M$49 VDD|VDD_DIV \$56 \$58 VDD|VDD_DIV pfet_03v3 L=0.28U W=2.5U AS=1.25P
+ AD=1.25P PS=6U PD=6U
M$50 VDD|VDD_DIV \$58 \$59 VDD|VDD_DIV pfet_03v3 L=0.28U W=2.5U AS=1.25P
+ AD=1.25P PS=6U PD=6U
M$51 VDD|VDD_DIV CK1|CKIN|CKOUT \$60 VDD|VDD_DIV pfet_03v3 L=0.28U W=2.5U
+ AS=1.25P AD=1.25P PS=6U PD=6U
M$52 VDD|VDD_DIV \$60 \$61 VDD|VDD_DIV pfet_03v3 L=0.28U W=2.5U AS=1.25P
+ AD=1.25P PS=6U PD=6U
M$53 \$59 \$61 \$62 VDD|VDD_DIV pfet_03v3 L=0.28U W=2.5U AS=1.25P AD=1.25P
+ PS=6U PD=6U
M$54 VDD|VDD_DIV \$62 \$63 VDD|VDD_DIV pfet_03v3 L=0.28U W=2.5U AS=1.25P
+ AD=1.25P PS=6U PD=6U
M$55 VDD|VDD_DIV \$63 \$64 VDD|VDD_DIV pfet_03v3 L=0.28U W=2.5U AS=1.25P
+ AD=1.25P PS=6U PD=6U
M$56 \$64 \$60 \$62 VDD|VDD_DIV pfet_03v3 L=0.28U W=2.5U AS=1.25P AD=1.25P
+ PS=6U PD=6U
M$57 \$63 \$60 \$65 VDD|VDD_DIV pfet_03v3 L=0.28U W=2.5U AS=1.25P AD=1.25P
+ PS=6U PD=6U
M$58 VDD|VDD_DIV \$65 MO1|MODOUT VDD|VDD_DIV pfet_03v3 L=0.28U W=2.5U AS=1.25P
+ AD=1.25P PS=6U PD=6U
M$59 VDD|VDD_DIV MO1|MODOUT \$66 VDD|VDD_DIV pfet_03v3 L=0.28U W=2.5U AS=1.25P
+ AD=1.25P PS=6U PD=6U
M$60 \$66 \$61 \$65 VDD|VDD_DIV pfet_03v3 L=0.28U W=2.5U AS=1.25P AD=1.25P
+ PS=6U PD=6U
M$61 VDD|VDD_DIV MI2|MODIN \$71 VDD|VDD_DIV pfet_03v3 L=0.28U W=2.5U AS=1.25P
+ AD=1.25P PS=6U PD=6U
M$62 VDD|VDD_DIV P|P2 \$71 VDD|VDD_DIV pfet_03v3 L=0.28U W=2.5U AS=1.25P
+ AD=1.25P PS=6U PD=6U
M$63 VDD|VDD_DIV MO2|MODOUT \$71 VDD|VDD_DIV pfet_03v3 L=0.28U W=2.5U AS=1.25P
+ AD=1.25P PS=6U PD=6U
M$64 VDD|VDD_DIV \$72 \$74 VDD|VDD_DIV pfet_03v3 L=0.28U W=2.5U AS=1.25P
+ AD=1.25P PS=6U PD=6U
M$65 VDD|VDD_DIV \$71 \$74 VDD|VDD_DIV pfet_03v3 L=0.28U W=2.5U AS=1.25P
+ AD=1.25P PS=6U PD=6U
M$66 VDD|VDD_DIV \$74 \$75 VDD|VDD_DIV pfet_03v3 L=0.28U W=2.5U AS=1.25P
+ AD=1.25P PS=6U PD=6U
M$67 VDD|VDD_DIV CK2|CKIN|CKOUT \$76 VDD|VDD_DIV pfet_03v3 L=0.28U W=2.5U
+ AS=1.25P AD=1.25P PS=6U PD=6U
M$68 VDD|VDD_DIV \$76 \$77 VDD|VDD_DIV pfet_03v3 L=0.28U W=2.5U AS=1.25P
+ AD=1.25P PS=6U PD=6U
M$69 \$75 \$77 \$78 VDD|VDD_DIV pfet_03v3 L=0.28U W=2.5U AS=1.25P AD=1.25P
+ PS=6U PD=6U
M$70 VDD|VDD_DIV \$78 \$79 VDD|VDD_DIV pfet_03v3 L=0.28U W=2.5U AS=1.25P
+ AD=1.25P PS=6U PD=6U
M$71 VDD|VDD_DIV \$79 \$80 VDD|VDD_DIV pfet_03v3 L=0.28U W=2.5U AS=1.25P
+ AD=1.25P PS=6U PD=6U
M$72 \$80 \$76 \$78 VDD|VDD_DIV pfet_03v3 L=0.28U W=2.5U AS=1.25P AD=1.25P
+ PS=6U PD=6U
M$73 \$79 \$76 \$81 VDD|VDD_DIV pfet_03v3 L=0.28U W=2.5U AS=1.25P AD=1.25P
+ PS=6U PD=6U
M$74 VDD|VDD_DIV \$81 \$82 VDD|VDD_DIV pfet_03v3 L=0.28U W=2.5U AS=1.25P
+ AD=1.25P PS=6U PD=6U
M$75 VDD|VDD_DIV \$82 \$72 VDD|VDD_DIV pfet_03v3 L=0.28U W=2.5U AS=1.25P
+ AD=1.25P PS=6U PD=6U
M$76 \$72 \$77 \$81 VDD|VDD_DIV pfet_03v3 L=0.28U W=2.5U AS=1.25P AD=1.25P
+ PS=6U PD=6U
M$77 VDD|VDD_DIV \$72 CK3|CKIN|CKOUT VDD|VDD_DIV pfet_03v3 L=0.28U W=5U AS=2.5P
+ AD=2.5P PS=11U PD=11U
M$78 VDD|VDD_DIV MI2|MODIN \$83 VDD|VDD_DIV pfet_03v3 L=0.28U W=2.5U AS=1.25P
+ AD=1.25P PS=6U PD=6U
M$79 VDD|VDD_DIV \$82 \$83 VDD|VDD_DIV pfet_03v3 L=0.28U W=2.5U AS=1.25P
+ AD=1.25P PS=6U PD=6U
M$80 VDD|VDD_DIV \$83 \$85 VDD|VDD_DIV pfet_03v3 L=0.28U W=2.5U AS=1.25P
+ AD=1.25P PS=6U PD=6U
M$81 VDD|VDD_DIV CK2|CKIN|CKOUT \$86 VDD|VDD_DIV pfet_03v3 L=0.28U W=2.5U
+ AS=1.25P AD=1.25P PS=6U PD=6U
M$82 VDD|VDD_DIV \$86 \$87 VDD|VDD_DIV pfet_03v3 L=0.28U W=2.5U AS=1.25P
+ AD=1.25P PS=6U PD=6U
M$83 \$85 \$87 \$88 VDD|VDD_DIV pfet_03v3 L=0.28U W=2.5U AS=1.25P AD=1.25P
+ PS=6U PD=6U
M$84 VDD|VDD_DIV \$88 \$89 VDD|VDD_DIV pfet_03v3 L=0.28U W=2.5U AS=1.25P
+ AD=1.25P PS=6U PD=6U
M$85 VDD|VDD_DIV \$89 \$90 VDD|VDD_DIV pfet_03v3 L=0.28U W=2.5U AS=1.25P
+ AD=1.25P PS=6U PD=6U
M$86 \$90 \$86 \$88 VDD|VDD_DIV pfet_03v3 L=0.28U W=2.5U AS=1.25P AD=1.25P
+ PS=6U PD=6U
M$87 \$89 \$86 \$91 VDD|VDD_DIV pfet_03v3 L=0.28U W=2.5U AS=1.25P AD=1.25P
+ PS=6U PD=6U
M$88 VDD|VDD_DIV \$91 MO2|MODOUT VDD|VDD_DIV pfet_03v3 L=0.28U W=2.5U AS=1.25P
+ AD=1.25P PS=6U PD=6U
M$89 VDD|VDD_DIV MO2|MODOUT \$92 VDD|VDD_DIV pfet_03v3 L=0.28U W=2.5U AS=1.25P
+ AD=1.25P PS=6U PD=6U
M$90 \$92 \$87 \$91 VDD|VDD_DIV pfet_03v3 L=0.28U W=2.5U AS=1.25P AD=1.25P
+ PS=6U PD=6U
M$91 VDD|VDD_DIV MI3|MODIN \$97 VDD|VDD_DIV pfet_03v3 L=0.28U W=2.5U AS=1.25P
+ AD=1.25P PS=6U PD=6U
M$92 VDD|VDD_DIV P|P3 \$97 VDD|VDD_DIV pfet_03v3 L=0.28U W=2.5U AS=1.25P
+ AD=1.25P PS=6U PD=6U
M$93 VDD|VDD_DIV MO3|MODOUT \$97 VDD|VDD_DIV pfet_03v3 L=0.28U W=2.5U AS=1.25P
+ AD=1.25P PS=6U PD=6U
M$94 VDD|VDD_DIV \$98 \$100 VDD|VDD_DIV pfet_03v3 L=0.28U W=2.5U AS=1.25P
+ AD=1.25P PS=6U PD=6U
M$95 VDD|VDD_DIV \$97 \$100 VDD|VDD_DIV pfet_03v3 L=0.28U W=2.5U AS=1.25P
+ AD=1.25P PS=6U PD=6U
M$96 VDD|VDD_DIV \$100 \$101 VDD|VDD_DIV pfet_03v3 L=0.28U W=2.5U AS=1.25P
+ AD=1.25P PS=6U PD=6U
M$97 VDD|VDD_DIV CK3|CKIN|CKOUT \$102 VDD|VDD_DIV pfet_03v3 L=0.28U W=2.5U
+ AS=1.25P AD=1.25P PS=6U PD=6U
M$98 VDD|VDD_DIV \$102 \$103 VDD|VDD_DIV pfet_03v3 L=0.28U W=2.5U AS=1.25P
+ AD=1.25P PS=6U PD=6U
M$99 \$101 \$103 \$104 VDD|VDD_DIV pfet_03v3 L=0.28U W=2.5U AS=1.25P AD=1.25P
+ PS=6U PD=6U
M$100 VDD|VDD_DIV \$104 \$105 VDD|VDD_DIV pfet_03v3 L=0.28U W=2.5U AS=1.25P
+ AD=1.25P PS=6U PD=6U
M$101 VDD|VDD_DIV \$105 \$106 VDD|VDD_DIV pfet_03v3 L=0.28U W=2.5U AS=1.25P
+ AD=1.25P PS=6U PD=6U
M$102 \$106 \$102 \$104 VDD|VDD_DIV pfet_03v3 L=0.28U W=2.5U AS=1.25P AD=1.25P
+ PS=6U PD=6U
M$103 \$105 \$102 \$107 VDD|VDD_DIV pfet_03v3 L=0.28U W=2.5U AS=1.25P AD=1.25P
+ PS=6U PD=6U
M$104 VDD|VDD_DIV \$107 \$108 VDD|VDD_DIV pfet_03v3 L=0.28U W=2.5U AS=1.25P
+ AD=1.25P PS=6U PD=6U
M$105 VDD|VDD_DIV \$108 \$98 VDD|VDD_DIV pfet_03v3 L=0.28U W=2.5U AS=1.25P
+ AD=1.25P PS=6U PD=6U
M$106 \$98 \$103 \$107 VDD|VDD_DIV pfet_03v3 L=0.28U W=2.5U AS=1.25P AD=1.25P
+ PS=6U PD=6U
M$107 VDD|VDD_DIV \$98 CK4|CKIN|CKOUT VDD|VDD_DIV pfet_03v3 L=0.28U W=5U
+ AS=2.5P AD=2.5P PS=11U PD=11U
M$108 VDD|VDD_DIV MI3|MODIN \$109 VDD|VDD_DIV pfet_03v3 L=0.28U W=2.5U AS=1.25P
+ AD=1.25P PS=6U PD=6U
M$109 VDD|VDD_DIV \$108 \$109 VDD|VDD_DIV pfet_03v3 L=0.28U W=2.5U AS=1.25P
+ AD=1.25P PS=6U PD=6U
M$110 VDD|VDD_DIV \$109 \$111 VDD|VDD_DIV pfet_03v3 L=0.28U W=2.5U AS=1.25P
+ AD=1.25P PS=6U PD=6U
M$111 VDD|VDD_DIV CK3|CKIN|CKOUT \$112 VDD|VDD_DIV pfet_03v3 L=0.28U W=2.5U
+ AS=1.25P AD=1.25P PS=6U PD=6U
M$112 VDD|VDD_DIV \$112 \$113 VDD|VDD_DIV pfet_03v3 L=0.28U W=2.5U AS=1.25P
+ AD=1.25P PS=6U PD=6U
M$113 \$111 \$113 \$114 VDD|VDD_DIV pfet_03v3 L=0.28U W=2.5U AS=1.25P AD=1.25P
+ PS=6U PD=6U
M$114 VDD|VDD_DIV \$114 \$115 VDD|VDD_DIV pfet_03v3 L=0.28U W=2.5U AS=1.25P
+ AD=1.25P PS=6U PD=6U
M$115 VDD|VDD_DIV \$115 \$116 VDD|VDD_DIV pfet_03v3 L=0.28U W=2.5U AS=1.25P
+ AD=1.25P PS=6U PD=6U
M$116 \$116 \$112 \$114 VDD|VDD_DIV pfet_03v3 L=0.28U W=2.5U AS=1.25P AD=1.25P
+ PS=6U PD=6U
M$117 \$115 \$112 \$117 VDD|VDD_DIV pfet_03v3 L=0.28U W=2.5U AS=1.25P AD=1.25P
+ PS=6U PD=6U
M$118 VDD|VDD_DIV \$117 MO3|MODOUT VDD|VDD_DIV pfet_03v3 L=0.28U W=2.5U
+ AS=1.25P AD=1.25P PS=6U PD=6U
M$119 VDD|VDD_DIV MO3|MODOUT \$118 VDD|VDD_DIV pfet_03v3 L=0.28U W=2.5U
+ AS=1.25P AD=1.25P PS=6U PD=6U
M$120 \$118 \$113 \$117 VDD|VDD_DIV pfet_03v3 L=0.28U W=2.5U AS=1.25P AD=1.25P
+ PS=6U PD=6U
M$121 VDD|VDD_DIV MI4|MODIN \$121 VDD|VDD_DIV pfet_03v3 L=0.28U W=2.5U AS=1.25P
+ AD=1.25P PS=6U PD=6U
M$122 VDD|VDD_DIV P|P4 \$121 VDD|VDD_DIV pfet_03v3 L=0.28U W=2.5U AS=1.25P
+ AD=1.25P PS=6U PD=6U
M$123 VDD|VDD_DIV MO4|MODOUT \$121 VDD|VDD_DIV pfet_03v3 L=0.28U W=2.5U
+ AS=1.25P AD=1.25P PS=6U PD=6U
M$124 VDD|VDD_DIV \$124 \$126 VDD|VDD_DIV pfet_03v3 L=0.28U W=2.5U AS=1.25P
+ AD=1.25P PS=6U PD=6U
M$125 VDD|VDD_DIV \$121 \$126 VDD|VDD_DIV pfet_03v3 L=0.28U W=2.5U AS=1.25P
+ AD=1.25P PS=6U PD=6U
M$126 VDD|VDD_DIV \$126 \$127 VDD|VDD_DIV pfet_03v3 L=0.28U W=2.5U AS=1.25P
+ AD=1.25P PS=6U PD=6U
M$127 VDD|VDD_DIV CK4|CKIN|CKOUT \$128 VDD|VDD_DIV pfet_03v3 L=0.28U W=2.5U
+ AS=1.25P AD=1.25P PS=6U PD=6U
M$128 VDD|VDD_DIV \$128 \$129 VDD|VDD_DIV pfet_03v3 L=0.28U W=2.5U AS=1.25P
+ AD=1.25P PS=6U PD=6U
M$129 \$127 \$129 \$130 VDD|VDD_DIV pfet_03v3 L=0.28U W=2.5U AS=1.25P AD=1.25P
+ PS=6U PD=6U
M$130 VDD|VDD_DIV \$130 \$131 VDD|VDD_DIV pfet_03v3 L=0.28U W=2.5U AS=1.25P
+ AD=1.25P PS=6U PD=6U
M$131 VDD|VDD_DIV \$131 \$132 VDD|VDD_DIV pfet_03v3 L=0.28U W=2.5U AS=1.25P
+ AD=1.25P PS=6U PD=6U
M$132 \$132 \$128 \$130 VDD|VDD_DIV pfet_03v3 L=0.28U W=2.5U AS=1.25P AD=1.25P
+ PS=6U PD=6U
M$133 \$131 \$128 \$133 VDD|VDD_DIV pfet_03v3 L=0.28U W=2.5U AS=1.25P AD=1.25P
+ PS=6U PD=6U
M$134 VDD|VDD_DIV \$133 \$134 VDD|VDD_DIV pfet_03v3 L=0.28U W=2.5U AS=1.25P
+ AD=1.25P PS=6U PD=6U
M$135 VDD|VDD_DIV \$134 \$124 VDD|VDD_DIV pfet_03v3 L=0.28U W=2.5U AS=1.25P
+ AD=1.25P PS=6U PD=6U
M$136 \$124 \$129 \$133 VDD|VDD_DIV pfet_03v3 L=0.28U W=2.5U AS=1.25P AD=1.25P
+ PS=6U PD=6U
M$137 VDD|VDD_DIV \$124 CK5|CKIN|CKOUT VDD|VDD_DIV pfet_03v3 L=0.28U W=5U
+ AS=2.5P AD=2.5P PS=11U PD=11U
M$138 VDD|VDD_DIV MI4|MODIN \$135 VDD|VDD_DIV pfet_03v3 L=0.28U W=2.5U AS=1.25P
+ AD=1.25P PS=6U PD=6U
M$139 VDD|VDD_DIV \$134 \$135 VDD|VDD_DIV pfet_03v3 L=0.28U W=2.5U AS=1.25P
+ AD=1.25P PS=6U PD=6U
M$140 VDD|VDD_DIV \$135 \$137 VDD|VDD_DIV pfet_03v3 L=0.28U W=2.5U AS=1.25P
+ AD=1.25P PS=6U PD=6U
M$141 VDD|VDD_DIV CK4|CKIN|CKOUT \$138 VDD|VDD_DIV pfet_03v3 L=0.28U W=2.5U
+ AS=1.25P AD=1.25P PS=6U PD=6U
M$142 VDD|VDD_DIV \$138 \$139 VDD|VDD_DIV pfet_03v3 L=0.28U W=2.5U AS=1.25P
+ AD=1.25P PS=6U PD=6U
M$143 \$137 \$139 \$140 VDD|VDD_DIV pfet_03v3 L=0.28U W=2.5U AS=1.25P AD=1.25P
+ PS=6U PD=6U
M$144 VDD|VDD_DIV \$140 \$141 VDD|VDD_DIV pfet_03v3 L=0.28U W=2.5U AS=1.25P
+ AD=1.25P PS=6U PD=6U
M$145 VDD|VDD_DIV \$141 \$142 VDD|VDD_DIV pfet_03v3 L=0.28U W=2.5U AS=1.25P
+ AD=1.25P PS=6U PD=6U
M$146 \$142 \$138 \$140 VDD|VDD_DIV pfet_03v3 L=0.28U W=2.5U AS=1.25P AD=1.25P
+ PS=6U PD=6U
M$147 \$141 \$138 \$143 VDD|VDD_DIV pfet_03v3 L=0.28U W=2.5U AS=1.25P AD=1.25P
+ PS=6U PD=6U
M$148 VDD|VDD_DIV \$143 MO4|MODOUT VDD|VDD_DIV pfet_03v3 L=0.28U W=2.5U
+ AS=1.25P AD=1.25P PS=6U PD=6U
M$149 VDD|VDD_DIV MO4|MODOUT \$144 VDD|VDD_DIV pfet_03v3 L=0.28U W=2.5U
+ AS=1.25P AD=1.25P PS=6U PD=6U
M$150 \$144 \$139 \$143 VDD|VDD_DIV pfet_03v3 L=0.28U W=2.5U AS=1.25P AD=1.25P
+ PS=6U PD=6U
M$151 VDD|VDD_DIV MODIN|SEL5 \$148 VDD|VDD_DIV pfet_03v3 L=0.28U W=2.5U
+ AS=1.25P AD=1.25P PS=6U PD=6U
M$152 VDD|VDD_DIV P|P5 \$148 VDD|VDD_DIV pfet_03v3 L=0.28U W=2.5U AS=1.25P
+ AD=1.25P PS=6U PD=6U
M$153 VDD|VDD_DIV MO5|MODOUT \$148 VDD|VDD_DIV pfet_03v3 L=0.28U W=2.5U
+ AS=1.25P AD=1.25P PS=6U PD=6U
M$154 VDD|VDD_DIV \$150 \$151 VDD|VDD_DIV pfet_03v3 L=0.28U W=2.5U AS=1.25P
+ AD=1.25P PS=6U PD=6U
M$155 VDD|VDD_DIV \$148 \$151 VDD|VDD_DIV pfet_03v3 L=0.28U W=2.5U AS=1.25P
+ AD=1.25P PS=6U PD=6U
M$156 VDD|VDD_DIV \$151 \$153 VDD|VDD_DIV pfet_03v3 L=0.28U W=2.5U AS=1.25P
+ AD=1.25P PS=6U PD=6U
M$157 VDD|VDD_DIV CK5|CKIN|CKOUT \$154 VDD|VDD_DIV pfet_03v3 L=0.28U W=2.5U
+ AS=1.25P AD=1.25P PS=6U PD=6U
M$158 VDD|VDD_DIV \$154 \$155 VDD|VDD_DIV pfet_03v3 L=0.28U W=2.5U AS=1.25P
+ AD=1.25P PS=6U PD=6U
M$159 \$153 \$155 \$156 VDD|VDD_DIV pfet_03v3 L=0.28U W=2.5U AS=1.25P AD=1.25P
+ PS=6U PD=6U
M$160 VDD|VDD_DIV \$156 \$157 VDD|VDD_DIV pfet_03v3 L=0.28U W=2.5U AS=1.25P
+ AD=1.25P PS=6U PD=6U
M$161 VDD|VDD_DIV \$157 \$158 VDD|VDD_DIV pfet_03v3 L=0.28U W=2.5U AS=1.25P
+ AD=1.25P PS=6U PD=6U
M$162 \$158 \$154 \$156 VDD|VDD_DIV pfet_03v3 L=0.28U W=2.5U AS=1.25P AD=1.25P
+ PS=6U PD=6U
M$163 \$157 \$154 \$159 VDD|VDD_DIV pfet_03v3 L=0.28U W=2.5U AS=1.25P AD=1.25P
+ PS=6U PD=6U
M$164 VDD|VDD_DIV \$159 \$160 VDD|VDD_DIV pfet_03v3 L=0.28U W=2.5U AS=1.25P
+ AD=1.25P PS=6U PD=6U
M$165 VDD|VDD_DIV \$160 \$150 VDD|VDD_DIV pfet_03v3 L=0.28U W=2.5U AS=1.25P
+ AD=1.25P PS=6U PD=6U
M$166 \$150 \$155 \$159 VDD|VDD_DIV pfet_03v3 L=0.28U W=2.5U AS=1.25P AD=1.25P
+ PS=6U PD=6U
M$167 VDD|VDD_DIV \$150 CK6|CKOUT VDD|VDD_DIV pfet_03v3 L=0.28U W=5U AS=2.5P
+ AD=2.5P PS=11U PD=11U
M$168 VDD|VDD_DIV MODIN|SEL5 \$163 VDD|VDD_DIV pfet_03v3 L=0.28U W=2.5U
+ AS=1.25P AD=1.25P PS=6U PD=6U
M$169 VDD|VDD_DIV \$160 \$163 VDD|VDD_DIV pfet_03v3 L=0.28U W=2.5U AS=1.25P
+ AD=1.25P PS=6U PD=6U
M$170 VDD|VDD_DIV \$163 \$164 VDD|VDD_DIV pfet_03v3 L=0.28U W=2.5U AS=1.25P
+ AD=1.25P PS=6U PD=6U
M$171 VDD|VDD_DIV CK5|CKIN|CKOUT \$165 VDD|VDD_DIV pfet_03v3 L=0.28U W=2.5U
+ AS=1.25P AD=1.25P PS=6U PD=6U
M$172 VDD|VDD_DIV \$165 \$166 VDD|VDD_DIV pfet_03v3 L=0.28U W=2.5U AS=1.25P
+ AD=1.25P PS=6U PD=6U
M$173 \$164 \$166 \$167 VDD|VDD_DIV pfet_03v3 L=0.28U W=2.5U AS=1.25P AD=1.25P
+ PS=6U PD=6U
M$174 VDD|VDD_DIV \$167 \$168 VDD|VDD_DIV pfet_03v3 L=0.28U W=2.5U AS=1.25P
+ AD=1.25P PS=6U PD=6U
M$175 VDD|VDD_DIV \$168 \$169 VDD|VDD_DIV pfet_03v3 L=0.28U W=2.5U AS=1.25P
+ AD=1.25P PS=6U PD=6U
M$176 \$169 \$165 \$167 VDD|VDD_DIV pfet_03v3 L=0.28U W=2.5U AS=1.25P AD=1.25P
+ PS=6U PD=6U
M$177 \$168 \$165 \$170 VDD|VDD_DIV pfet_03v3 L=0.28U W=2.5U AS=1.25P AD=1.25P
+ PS=6U PD=6U
M$178 VDD|VDD_DIV \$170 MO5|MODOUT VDD|VDD_DIV pfet_03v3 L=0.28U W=2.5U
+ AS=1.25P AD=1.25P PS=6U PD=6U
M$179 VDD|VDD_DIV MO5|MODOUT \$171 VDD|VDD_DIV pfet_03v3 L=0.28U W=2.5U
+ AS=1.25P AD=1.25P PS=6U PD=6U
M$180 \$171 \$166 \$170 VDD|VDD_DIV pfet_03v3 L=0.28U W=2.5U AS=1.25P AD=1.25P
+ PS=6U PD=6U
M$181 XNR0_PMID SEL0 NMI0 VDD|VDD_DIV pfet_03v3 L=0.28U W=5U AS=2.5P AD=2.5P
+ PS=11U PD=11U
M$182 VDD|VDD_DIV NMI0 MI0|MODIN VDD|VDD_DIV pfet_03v3 L=0.28U W=2.5U AS=1.25P
+ AD=1.25P PS=6U PD=6U
M$183 XNR1_PMID SEL1 NMI1 VDD|VDD_DIV pfet_03v3 L=0.28U W=5U AS=2.5P AD=2.5P
+ PS=11U PD=11U
M$184 VDD|VDD_DIV NMI1 MI1|MODIN VDD|VDD_DIV pfet_03v3 L=0.28U W=2.5U AS=1.25P
+ AD=1.25P PS=6U PD=6U
M$185 XNR2_PMID SEL2 NMI2 VDD|VDD_DIV pfet_03v3 L=0.28U W=5U AS=2.5P AD=2.5P
+ PS=11U PD=11U
M$186 VDD|VDD_DIV NMI2 MI2|MODIN VDD|VDD_DIV pfet_03v3 L=0.28U W=2.5U AS=1.25P
+ AD=1.25P PS=6U PD=6U
M$187 XNR3_PMID SEL3 NMI3 VDD|VDD_DIV pfet_03v3 L=0.28U W=5U AS=2.5P AD=2.5P
+ PS=11U PD=11U
M$188 VDD|VDD_DIV NMI3 MI3|MODIN VDD|VDD_DIV pfet_03v3 L=0.28U W=2.5U AS=1.25P
+ AD=1.25P PS=6U PD=6U
M$189 XNR4_PMID SEL4 NMI4 VDD|VDD_DIV pfet_03v3 L=0.28U W=5U AS=2.5P AD=2.5P
+ PS=11U PD=11U
M$190 VDD|VDD_DIV NMI4 MI4|MODIN VDD|VDD_DIV pfet_03v3 L=0.28U W=2.5U AS=1.25P
+ AD=1.25P PS=6U PD=6U
M$191 VDD|VDD_DIV CK1|CKIN|CKOUT T0 VDD|VDD_DIV pfet_03v3 L=0.28U W=2.5U
+ AS=1.25P AD=1.25P PS=6U PD=6U
M$192 VDD|VDD_DIV SEL0 T0 VDD|VDD_DIV pfet_03v3 L=0.28U W=2.5U AS=1.25P
+ AD=1.25P PS=6U PD=6U
M$193 VDD|VDD_DIV CK2|CKIN|CKOUT T1 VDD|VDD_DIV pfet_03v3 L=0.28U W=2.5U
+ AS=1.25P AD=1.25P PS=6U PD=6U
M$194 VDD|VDD_DIV SEL1 T1 VDD|VDD_DIV pfet_03v3 L=0.28U W=2.5U AS=1.25P
+ AD=1.25P PS=6U PD=6U
M$195 VDD|VDD_DIV CK3|CKIN|CKOUT T2 VDD|VDD_DIV pfet_03v3 L=0.28U W=2.5U
+ AS=1.25P AD=1.25P PS=6U PD=6U
M$196 VDD|VDD_DIV SEL2 T2 VDD|VDD_DIV pfet_03v3 L=0.28U W=2.5U AS=1.25P
+ AD=1.25P PS=6U PD=6U
M$197 VDD|VDD_DIV CK4|CKIN|CKOUT T3 VDD|VDD_DIV pfet_03v3 L=0.28U W=2.5U
+ AS=1.25P AD=1.25P PS=6U PD=6U
M$198 VDD|VDD_DIV SEL3 T3 VDD|VDD_DIV pfet_03v3 L=0.28U W=2.5U AS=1.25P
+ AD=1.25P PS=6U PD=6U
M$199 VDD|VDD_DIV CK5|CKIN|CKOUT T4 VDD|VDD_DIV pfet_03v3 L=0.28U W=2.5U
+ AS=1.25P AD=1.25P PS=6U PD=6U
M$200 VDD|VDD_DIV SEL4 T4 VDD|VDD_DIV pfet_03v3 L=0.28U W=2.5U AS=1.25P
+ AD=1.25P PS=6U PD=6U
M$201 VDD|VDD_DIV CK6|CKOUT T5 VDD|VDD_DIV pfet_03v3 L=0.28U W=2.5U AS=1.25P
+ AD=1.25P PS=6U PD=6U
M$202 VDD|VDD_DIV MODIN|SEL5 T5 VDD|VDD_DIV pfet_03v3 L=0.28U W=2.5U AS=1.25P
+ AD=1.25P PS=6U PD=6U
M$203 VDD|VDD_DIV T0 MA VDD|VDD_DIV pfet_03v3 L=0.28U W=2.5U AS=1.25P AD=1.25P
+ PS=6U PD=6U
M$204 VDD|VDD_DIV T1 MA VDD|VDD_DIV pfet_03v3 L=0.28U W=2.5U AS=1.25P AD=1.25P
+ PS=6U PD=6U
M$205 VDD|VDD_DIV T2 MA VDD|VDD_DIV pfet_03v3 L=0.28U W=2.5U AS=1.25P AD=1.25P
+ PS=6U PD=6U
M$206 VDD|VDD_DIV T3 MB VDD|VDD_DIV pfet_03v3 L=0.28U W=2.5U AS=1.25P AD=1.25P
+ PS=6U PD=6U
M$207 VDD|VDD_DIV T4 MB VDD|VDD_DIV pfet_03v3 L=0.28U W=2.5U AS=1.25P AD=1.25P
+ PS=6U PD=6U
M$208 VDD|VDD_DIV T5 MB VDD|VDD_DIV pfet_03v3 L=0.28U W=2.5U AS=1.25P AD=1.25P
+ PS=6U PD=6U
M$209 XMNO_PMID MB DIVOUTB VDD|VDD_DIV pfet_03v3 L=0.28U W=5U AS=2.5P AD=2.5P
+ PS=11U PD=11U
M$210 VDD|VDD_DIV DIVOUTB DIVOUT VDD|VDD_DIV pfet_03v3 L=0.28U W=5U AS=2.5P
+ AD=2.5P PS=11U PD=11U
M$211 VDD|VDD_DIV CKIN|VCO XFRT_CKB VDD|VDD_DIV pfet_03v3 L=0.28U W=2.5U
+ AS=1.25P AD=1.25P PS=6U PD=6U
M$212 VDD|VDD_DIV XFRT_CKB XFRT_CKBB VDD|VDD_DIV pfet_03v3 L=0.28U W=2.5U
+ AS=1.25P AD=1.25P PS=6U PD=6U
M$213 DIVOUT XFRT_CKBB XFRT_NM VDD|VDD_DIV pfet_03v3 L=0.28U W=2.5U AS=1.25P
+ AD=1.25P PS=6U PD=6U
M$214 VDD|VDD_DIV XFRT_NM XFRT_NMA VDD|VDD_DIV pfet_03v3 L=0.28U W=2.5U
+ AS=1.25P AD=1.25P PS=6U PD=6U
M$215 VDD|VDD_DIV XFRT_NMA XFRT_NMB VDD|VDD_DIV pfet_03v3 L=0.28U W=2.5U
+ AS=1.25P AD=1.25P PS=6U PD=6U
M$216 XFRT_NMB XFRT_CKB XFRT_NM VDD|VDD_DIV pfet_03v3 L=0.28U W=2.5U AS=1.25P
+ AD=1.25P PS=6U PD=6U
M$217 XFRT_NMA XFRT_CKB XFRT_NS VDD|VDD_DIV pfet_03v3 L=0.28U W=2.5U AS=1.25P
+ AD=1.25P PS=6U PD=6U
M$218 VDD|VDD_DIV XFRT_NS FB VDD|VDD_DIV pfet_03v3 L=0.28U W=2.5U AS=1.25P
+ AD=1.25P PS=6U PD=6U
M$219 VDD|VDD_DIV FB FBB VDD|VDD_DIV pfet_03v3 L=0.28U W=2.5U AS=1.25P AD=1.25P
+ PS=6U PD=6U
M$220 FBB XFRT_CKBB XFRT_NS VDD|VDD_DIV pfet_03v3 L=0.28U W=2.5U AS=1.25P
+ AD=1.25P PS=6U PD=6U
M$221 VDD|VDD_DIV MO1|MODOUT XNR0_PMID VDD|VDD_DIV pfet_03v3 L=0.28U W=5U
+ AS=2.5P AD=2.5P PS=11U PD=11U
M$222 VDD|VDD_DIV MO2|MODOUT XNR1_PMID VDD|VDD_DIV pfet_03v3 L=0.28U W=5U
+ AS=2.5P AD=2.5P PS=11U PD=11U
M$223 VDD|VDD_DIV MO3|MODOUT XNR2_PMID VDD|VDD_DIV pfet_03v3 L=0.28U W=5U
+ AS=2.5P AD=2.5P PS=11U PD=11U
M$224 VDD|VDD_DIV MO4|MODOUT XNR3_PMID VDD|VDD_DIV pfet_03v3 L=0.28U W=5U
+ AS=2.5P AD=2.5P PS=11U PD=11U
M$225 VDD|VDD_DIV MO5|MODOUT XNR4_PMID VDD|VDD_DIV pfet_03v3 L=0.28U W=5U
+ AS=2.5P AD=2.5P PS=11U PD=11U
M$226 VDD|VDD_DIV MA XMNO_PMID VDD|VDD_DIV pfet_03v3 L=0.28U W=5U AS=2.5P
+ AD=2.5P PS=11U PD=11U
M$227 \$16 MO0|MODOUT VSS VSS nfet_03v3 L=0.28U W=3U AS=1.5P AD=1.5P PS=7U PD=7U
M$228 \$22 \$18 VSS VSS nfet_03v3 L=0.28U W=2U AS=1P AD=1P PS=5U PD=5U
M$229 \$23 \$21 VSS VSS nfet_03v3 L=0.28U W=1U AS=0.5P AD=0.5P PS=3U PD=3U
M$230 \$24 CKIN|VCO VSS VSS nfet_03v3 L=0.28U W=1U AS=0.5P AD=0.5P PS=3U PD=3U
M$231 \$25 \$24 VSS VSS nfet_03v3 L=0.28U W=1U AS=0.5P AD=0.5P PS=3U PD=3U
M$232 \$26 \$24 \$23 VSS nfet_03v3 L=0.28U W=1U AS=0.5P AD=0.5P PS=3U PD=3U
M$233 \$27 \$26 VSS VSS nfet_03v3 L=0.28U W=1U AS=0.5P AD=0.5P PS=3U PD=3U
M$234 \$28 \$27 VSS VSS nfet_03v3 L=0.28U W=1U AS=0.5P AD=0.5P PS=3U PD=3U
M$235 \$26 \$25 \$28 VSS nfet_03v3 L=0.28U W=1U AS=0.5P AD=0.5P PS=3U PD=3U
M$236 \$29 \$25 \$27 VSS nfet_03v3 L=0.28U W=1U AS=0.5P AD=0.5P PS=3U PD=3U
M$237 \$30 \$29 VSS VSS nfet_03v3 L=0.28U W=1U AS=0.5P AD=0.5P PS=3U PD=3U
M$238 \$20 \$30 VSS VSS nfet_03v3 L=0.28U W=1U AS=0.5P AD=0.5P PS=3U PD=3U
M$239 \$29 \$24 \$20 VSS nfet_03v3 L=0.28U W=1U AS=0.5P AD=0.5P PS=3U PD=3U
M$240 CK1|CKIN|CKOUT \$20 VSS VSS nfet_03v3 L=0.28U W=2U AS=1P AD=1P PS=5U PD=5U
M$241 \$32 \$30 VSS VSS nfet_03v3 L=0.28U W=2U AS=1P AD=1P PS=5U PD=5U
M$242 \$33 \$31 VSS VSS nfet_03v3 L=0.28U W=1U AS=0.5P AD=0.5P PS=3U PD=3U
M$243 \$34 CKIN|VCO VSS VSS nfet_03v3 L=0.28U W=1U AS=0.5P AD=0.5P PS=3U PD=3U
M$244 \$35 \$34 VSS VSS nfet_03v3 L=0.28U W=1U AS=0.5P AD=0.5P PS=3U PD=3U
M$245 \$36 \$34 \$33 VSS nfet_03v3 L=0.28U W=1U AS=0.5P AD=0.5P PS=3U PD=3U
M$246 \$37 \$36 VSS VSS nfet_03v3 L=0.28U W=1U AS=0.5P AD=0.5P PS=3U PD=3U
M$247 \$38 \$37 VSS VSS nfet_03v3 L=0.28U W=1U AS=0.5P AD=0.5P PS=3U PD=3U
M$248 \$36 \$35 \$38 VSS nfet_03v3 L=0.28U W=1U AS=0.5P AD=0.5P PS=3U PD=3U
M$249 \$39 \$35 \$37 VSS nfet_03v3 L=0.28U W=1U AS=0.5P AD=0.5P PS=3U PD=3U
M$250 MO0|MODOUT \$39 VSS VSS nfet_03v3 L=0.28U W=1U AS=0.5P AD=0.5P PS=3U PD=3U
M$251 \$40 MO0|MODOUT VSS VSS nfet_03v3 L=0.28U W=1U AS=0.5P AD=0.5P PS=3U PD=3U
M$252 \$39 \$34 \$40 VSS nfet_03v3 L=0.28U W=1U AS=0.5P AD=0.5P PS=3U PD=3U
M$253 \$43 MO1|MODOUT VSS VSS nfet_03v3 L=0.28U W=3U AS=1.5P AD=1.5P PS=7U PD=7U
M$254 \$47 \$45 VSS VSS nfet_03v3 L=0.28U W=2U AS=1P AD=1P PS=5U PD=5U
M$255 \$49 \$48 VSS VSS nfet_03v3 L=0.28U W=1U AS=0.5P AD=0.5P PS=3U PD=3U
M$256 \$50 CK1|CKIN|CKOUT VSS VSS nfet_03v3 L=0.28U W=1U AS=0.5P AD=0.5P PS=3U
+ PD=3U
M$257 \$51 \$50 VSS VSS nfet_03v3 L=0.28U W=1U AS=0.5P AD=0.5P PS=3U PD=3U
M$258 \$52 \$50 \$49 VSS nfet_03v3 L=0.28U W=1U AS=0.5P AD=0.5P PS=3U PD=3U
M$259 \$53 \$52 VSS VSS nfet_03v3 L=0.28U W=1U AS=0.5P AD=0.5P PS=3U PD=3U
M$260 \$54 \$53 VSS VSS nfet_03v3 L=0.28U W=1U AS=0.5P AD=0.5P PS=3U PD=3U
M$261 \$52 \$51 \$54 VSS nfet_03v3 L=0.28U W=1U AS=0.5P AD=0.5P PS=3U PD=3U
M$262 \$55 \$51 \$53 VSS nfet_03v3 L=0.28U W=1U AS=0.5P AD=0.5P PS=3U PD=3U
M$263 \$56 \$55 VSS VSS nfet_03v3 L=0.28U W=1U AS=0.5P AD=0.5P PS=3U PD=3U
M$264 \$46 \$56 VSS VSS nfet_03v3 L=0.28U W=1U AS=0.5P AD=0.5P PS=3U PD=3U
M$265 \$55 \$50 \$46 VSS nfet_03v3 L=0.28U W=1U AS=0.5P AD=0.5P PS=3U PD=3U
M$266 CK2|CKIN|CKOUT \$46 VSS VSS nfet_03v3 L=0.28U W=2U AS=1P AD=1P PS=5U PD=5U
M$267 \$57 \$56 VSS VSS nfet_03v3 L=0.28U W=2U AS=1P AD=1P PS=5U PD=5U
M$268 \$59 \$58 VSS VSS nfet_03v3 L=0.28U W=1U AS=0.5P AD=0.5P PS=3U PD=3U
M$269 \$60 CK1|CKIN|CKOUT VSS VSS nfet_03v3 L=0.28U W=1U AS=0.5P AD=0.5P PS=3U
+ PD=3U
M$270 \$61 \$60 VSS VSS nfet_03v3 L=0.28U W=1U AS=0.5P AD=0.5P PS=3U PD=3U
M$271 \$62 \$60 \$59 VSS nfet_03v3 L=0.28U W=1U AS=0.5P AD=0.5P PS=3U PD=3U
M$272 \$63 \$62 VSS VSS nfet_03v3 L=0.28U W=1U AS=0.5P AD=0.5P PS=3U PD=3U
M$273 \$64 \$63 VSS VSS nfet_03v3 L=0.28U W=1U AS=0.5P AD=0.5P PS=3U PD=3U
M$274 \$62 \$61 \$64 VSS nfet_03v3 L=0.28U W=1U AS=0.5P AD=0.5P PS=3U PD=3U
M$275 \$65 \$61 \$63 VSS nfet_03v3 L=0.28U W=1U AS=0.5P AD=0.5P PS=3U PD=3U
M$276 MO1|MODOUT \$65 VSS VSS nfet_03v3 L=0.28U W=1U AS=0.5P AD=0.5P PS=3U PD=3U
M$277 \$66 MO1|MODOUT VSS VSS nfet_03v3 L=0.28U W=1U AS=0.5P AD=0.5P PS=3U PD=3U
M$278 \$65 \$60 \$66 VSS nfet_03v3 L=0.28U W=1U AS=0.5P AD=0.5P PS=3U PD=3U
M$279 \$70 MO2|MODOUT VSS VSS nfet_03v3 L=0.28U W=3U AS=1.5P AD=1.5P PS=7U PD=7U
M$280 \$73 \$71 VSS VSS nfet_03v3 L=0.28U W=2U AS=1P AD=1P PS=5U PD=5U
M$281 \$75 \$74 VSS VSS nfet_03v3 L=0.28U W=1U AS=0.5P AD=0.5P PS=3U PD=3U
M$282 \$76 CK2|CKIN|CKOUT VSS VSS nfet_03v3 L=0.28U W=1U AS=0.5P AD=0.5P PS=3U
+ PD=3U
M$283 \$77 \$76 VSS VSS nfet_03v3 L=0.28U W=1U AS=0.5P AD=0.5P PS=3U PD=3U
M$284 \$78 \$76 \$75 VSS nfet_03v3 L=0.28U W=1U AS=0.5P AD=0.5P PS=3U PD=3U
M$285 \$79 \$78 VSS VSS nfet_03v3 L=0.28U W=1U AS=0.5P AD=0.5P PS=3U PD=3U
M$286 \$80 \$79 VSS VSS nfet_03v3 L=0.28U W=1U AS=0.5P AD=0.5P PS=3U PD=3U
M$287 \$78 \$77 \$80 VSS nfet_03v3 L=0.28U W=1U AS=0.5P AD=0.5P PS=3U PD=3U
M$288 \$81 \$77 \$79 VSS nfet_03v3 L=0.28U W=1U AS=0.5P AD=0.5P PS=3U PD=3U
M$289 \$82 \$81 VSS VSS nfet_03v3 L=0.28U W=1U AS=0.5P AD=0.5P PS=3U PD=3U
M$290 \$72 \$82 VSS VSS nfet_03v3 L=0.28U W=1U AS=0.5P AD=0.5P PS=3U PD=3U
M$291 \$81 \$76 \$72 VSS nfet_03v3 L=0.28U W=1U AS=0.5P AD=0.5P PS=3U PD=3U
M$292 CK3|CKIN|CKOUT \$72 VSS VSS nfet_03v3 L=0.28U W=2U AS=1P AD=1P PS=5U PD=5U
M$293 \$84 \$82 VSS VSS nfet_03v3 L=0.28U W=2U AS=1P AD=1P PS=5U PD=5U
M$294 \$85 \$83 VSS VSS nfet_03v3 L=0.28U W=1U AS=0.5P AD=0.5P PS=3U PD=3U
M$295 \$86 CK2|CKIN|CKOUT VSS VSS nfet_03v3 L=0.28U W=1U AS=0.5P AD=0.5P PS=3U
+ PD=3U
M$296 \$87 \$86 VSS VSS nfet_03v3 L=0.28U W=1U AS=0.5P AD=0.5P PS=3U PD=3U
M$297 \$88 \$86 \$85 VSS nfet_03v3 L=0.28U W=1U AS=0.5P AD=0.5P PS=3U PD=3U
M$298 \$89 \$88 VSS VSS nfet_03v3 L=0.28U W=1U AS=0.5P AD=0.5P PS=3U PD=3U
M$299 \$90 \$89 VSS VSS nfet_03v3 L=0.28U W=1U AS=0.5P AD=0.5P PS=3U PD=3U
M$300 \$88 \$87 \$90 VSS nfet_03v3 L=0.28U W=1U AS=0.5P AD=0.5P PS=3U PD=3U
M$301 \$91 \$87 \$89 VSS nfet_03v3 L=0.28U W=1U AS=0.5P AD=0.5P PS=3U PD=3U
M$302 MO2|MODOUT \$91 VSS VSS nfet_03v3 L=0.28U W=1U AS=0.5P AD=0.5P PS=3U PD=3U
M$303 \$92 MO2|MODOUT VSS VSS nfet_03v3 L=0.28U W=1U AS=0.5P AD=0.5P PS=3U PD=3U
M$304 \$91 \$86 \$92 VSS nfet_03v3 L=0.28U W=1U AS=0.5P AD=0.5P PS=3U PD=3U
M$305 \$95 MO3|MODOUT VSS VSS nfet_03v3 L=0.28U W=3U AS=1.5P AD=1.5P PS=7U PD=7U
M$306 \$99 \$97 VSS VSS nfet_03v3 L=0.28U W=2U AS=1P AD=1P PS=5U PD=5U
M$307 \$101 \$100 VSS VSS nfet_03v3 L=0.28U W=1U AS=0.5P AD=0.5P PS=3U PD=3U
M$308 \$102 CK3|CKIN|CKOUT VSS VSS nfet_03v3 L=0.28U W=1U AS=0.5P AD=0.5P PS=3U
+ PD=3U
M$309 \$103 \$102 VSS VSS nfet_03v3 L=0.28U W=1U AS=0.5P AD=0.5P PS=3U PD=3U
M$310 \$104 \$102 \$101 VSS nfet_03v3 L=0.28U W=1U AS=0.5P AD=0.5P PS=3U PD=3U
M$311 \$105 \$104 VSS VSS nfet_03v3 L=0.28U W=1U AS=0.5P AD=0.5P PS=3U PD=3U
M$312 \$106 \$105 VSS VSS nfet_03v3 L=0.28U W=1U AS=0.5P AD=0.5P PS=3U PD=3U
M$313 \$104 \$103 \$106 VSS nfet_03v3 L=0.28U W=1U AS=0.5P AD=0.5P PS=3U PD=3U
M$314 \$107 \$103 \$105 VSS nfet_03v3 L=0.28U W=1U AS=0.5P AD=0.5P PS=3U PD=3U
M$315 \$108 \$107 VSS VSS nfet_03v3 L=0.28U W=1U AS=0.5P AD=0.5P PS=3U PD=3U
M$316 \$98 \$108 VSS VSS nfet_03v3 L=0.28U W=1U AS=0.5P AD=0.5P PS=3U PD=3U
M$317 \$107 \$102 \$98 VSS nfet_03v3 L=0.28U W=1U AS=0.5P AD=0.5P PS=3U PD=3U
M$318 CK4|CKIN|CKOUT \$98 VSS VSS nfet_03v3 L=0.28U W=2U AS=1P AD=1P PS=5U PD=5U
M$319 \$110 \$108 VSS VSS nfet_03v3 L=0.28U W=2U AS=1P AD=1P PS=5U PD=5U
M$320 \$111 \$109 VSS VSS nfet_03v3 L=0.28U W=1U AS=0.5P AD=0.5P PS=3U PD=3U
M$321 \$112 CK3|CKIN|CKOUT VSS VSS nfet_03v3 L=0.28U W=1U AS=0.5P AD=0.5P PS=3U
+ PD=3U
M$322 \$113 \$112 VSS VSS nfet_03v3 L=0.28U W=1U AS=0.5P AD=0.5P PS=3U PD=3U
M$323 \$114 \$112 \$111 VSS nfet_03v3 L=0.28U W=1U AS=0.5P AD=0.5P PS=3U PD=3U
M$324 \$115 \$114 VSS VSS nfet_03v3 L=0.28U W=1U AS=0.5P AD=0.5P PS=3U PD=3U
M$325 \$116 \$115 VSS VSS nfet_03v3 L=0.28U W=1U AS=0.5P AD=0.5P PS=3U PD=3U
M$326 \$114 \$113 \$116 VSS nfet_03v3 L=0.28U W=1U AS=0.5P AD=0.5P PS=3U PD=3U
M$327 \$117 \$113 \$115 VSS nfet_03v3 L=0.28U W=1U AS=0.5P AD=0.5P PS=3U PD=3U
M$328 MO3|MODOUT \$117 VSS VSS nfet_03v3 L=0.28U W=1U AS=0.5P AD=0.5P PS=3U
+ PD=3U
M$329 \$118 MO3|MODOUT VSS VSS nfet_03v3 L=0.28U W=1U AS=0.5P AD=0.5P PS=3U
+ PD=3U
M$330 \$117 \$112 \$118 VSS nfet_03v3 L=0.28U W=1U AS=0.5P AD=0.5P PS=3U PD=3U
M$331 \$123 MO4|MODOUT VSS VSS nfet_03v3 L=0.28U W=3U AS=1.5P AD=1.5P PS=7U
+ PD=7U
M$332 \$125 \$121 VSS VSS nfet_03v3 L=0.28U W=2U AS=1P AD=1P PS=5U PD=5U
M$333 \$127 \$126 VSS VSS nfet_03v3 L=0.28U W=1U AS=0.5P AD=0.5P PS=3U PD=3U
M$334 \$128 CK4|CKIN|CKOUT VSS VSS nfet_03v3 L=0.28U W=1U AS=0.5P AD=0.5P PS=3U
+ PD=3U
M$335 \$129 \$128 VSS VSS nfet_03v3 L=0.28U W=1U AS=0.5P AD=0.5P PS=3U PD=3U
M$336 \$130 \$128 \$127 VSS nfet_03v3 L=0.28U W=1U AS=0.5P AD=0.5P PS=3U PD=3U
M$337 \$131 \$130 VSS VSS nfet_03v3 L=0.28U W=1U AS=0.5P AD=0.5P PS=3U PD=3U
M$338 \$132 \$131 VSS VSS nfet_03v3 L=0.28U W=1U AS=0.5P AD=0.5P PS=3U PD=3U
M$339 \$130 \$129 \$132 VSS nfet_03v3 L=0.28U W=1U AS=0.5P AD=0.5P PS=3U PD=3U
M$340 \$133 \$129 \$131 VSS nfet_03v3 L=0.28U W=1U AS=0.5P AD=0.5P PS=3U PD=3U
M$341 \$134 \$133 VSS VSS nfet_03v3 L=0.28U W=1U AS=0.5P AD=0.5P PS=3U PD=3U
M$342 \$124 \$134 VSS VSS nfet_03v3 L=0.28U W=1U AS=0.5P AD=0.5P PS=3U PD=3U
M$343 \$133 \$128 \$124 VSS nfet_03v3 L=0.28U W=1U AS=0.5P AD=0.5P PS=3U PD=3U
M$344 CK5|CKIN|CKOUT \$124 VSS VSS nfet_03v3 L=0.28U W=2U AS=1P AD=1P PS=5U
+ PD=5U
M$345 \$136 \$134 VSS VSS nfet_03v3 L=0.28U W=2U AS=1P AD=1P PS=5U PD=5U
M$346 \$137 \$135 VSS VSS nfet_03v3 L=0.28U W=1U AS=0.5P AD=0.5P PS=3U PD=3U
M$347 \$138 CK4|CKIN|CKOUT VSS VSS nfet_03v3 L=0.28U W=1U AS=0.5P AD=0.5P PS=3U
+ PD=3U
M$348 \$139 \$138 VSS VSS nfet_03v3 L=0.28U W=1U AS=0.5P AD=0.5P PS=3U PD=3U
M$349 \$140 \$138 \$137 VSS nfet_03v3 L=0.28U W=1U AS=0.5P AD=0.5P PS=3U PD=3U
M$350 \$141 \$140 VSS VSS nfet_03v3 L=0.28U W=1U AS=0.5P AD=0.5P PS=3U PD=3U
M$351 \$142 \$141 VSS VSS nfet_03v3 L=0.28U W=1U AS=0.5P AD=0.5P PS=3U PD=3U
M$352 \$140 \$139 \$142 VSS nfet_03v3 L=0.28U W=1U AS=0.5P AD=0.5P PS=3U PD=3U
M$353 \$143 \$139 \$141 VSS nfet_03v3 L=0.28U W=1U AS=0.5P AD=0.5P PS=3U PD=3U
M$354 MO4|MODOUT \$143 VSS VSS nfet_03v3 L=0.28U W=1U AS=0.5P AD=0.5P PS=3U
+ PD=3U
M$355 \$144 MO4|MODOUT VSS VSS nfet_03v3 L=0.28U W=1U AS=0.5P AD=0.5P PS=3U
+ PD=3U
M$356 \$143 \$138 \$144 VSS nfet_03v3 L=0.28U W=1U AS=0.5P AD=0.5P PS=3U PD=3U
M$357 \$147 MO5|MODOUT VSS VSS nfet_03v3 L=0.28U W=3U AS=1.5P AD=1.5P PS=7U
+ PD=7U
M$358 \$152 \$148 VSS VSS nfet_03v3 L=0.28U W=2U AS=1P AD=1P PS=5U PD=5U
M$359 \$153 \$151 VSS VSS nfet_03v3 L=0.28U W=1U AS=0.5P AD=0.5P PS=3U PD=3U
M$360 \$154 CK5|CKIN|CKOUT VSS VSS nfet_03v3 L=0.28U W=1U AS=0.5P AD=0.5P PS=3U
+ PD=3U
M$361 \$155 \$154 VSS VSS nfet_03v3 L=0.28U W=1U AS=0.5P AD=0.5P PS=3U PD=3U
M$362 \$156 \$154 \$153 VSS nfet_03v3 L=0.28U W=1U AS=0.5P AD=0.5P PS=3U PD=3U
M$363 \$157 \$156 VSS VSS nfet_03v3 L=0.28U W=1U AS=0.5P AD=0.5P PS=3U PD=3U
M$364 \$158 \$157 VSS VSS nfet_03v3 L=0.28U W=1U AS=0.5P AD=0.5P PS=3U PD=3U
M$365 \$156 \$155 \$158 VSS nfet_03v3 L=0.28U W=1U AS=0.5P AD=0.5P PS=3U PD=3U
M$366 \$159 \$155 \$157 VSS nfet_03v3 L=0.28U W=1U AS=0.5P AD=0.5P PS=3U PD=3U
M$367 \$160 \$159 VSS VSS nfet_03v3 L=0.28U W=1U AS=0.5P AD=0.5P PS=3U PD=3U
M$368 \$150 \$160 VSS VSS nfet_03v3 L=0.28U W=1U AS=0.5P AD=0.5P PS=3U PD=3U
M$369 \$159 \$154 \$150 VSS nfet_03v3 L=0.28U W=1U AS=0.5P AD=0.5P PS=3U PD=3U
M$370 CK6|CKOUT \$150 VSS VSS nfet_03v3 L=0.28U W=2U AS=1P AD=1P PS=5U PD=5U
M$371 \$162 \$160 VSS VSS nfet_03v3 L=0.28U W=2U AS=1P AD=1P PS=5U PD=5U
M$372 \$164 \$163 VSS VSS nfet_03v3 L=0.28U W=1U AS=0.5P AD=0.5P PS=3U PD=3U
M$373 \$165 CK5|CKIN|CKOUT VSS VSS nfet_03v3 L=0.28U W=1U AS=0.5P AD=0.5P PS=3U
+ PD=3U
M$374 \$166 \$165 VSS VSS nfet_03v3 L=0.28U W=1U AS=0.5P AD=0.5P PS=3U PD=3U
M$375 \$167 \$165 \$164 VSS nfet_03v3 L=0.28U W=1U AS=0.5P AD=0.5P PS=3U PD=3U
M$376 \$168 \$167 VSS VSS nfet_03v3 L=0.28U W=1U AS=0.5P AD=0.5P PS=3U PD=3U
M$377 \$169 \$168 VSS VSS nfet_03v3 L=0.28U W=1U AS=0.5P AD=0.5P PS=3U PD=3U
M$378 \$167 \$166 \$169 VSS nfet_03v3 L=0.28U W=1U AS=0.5P AD=0.5P PS=3U PD=3U
M$379 \$170 \$166 \$168 VSS nfet_03v3 L=0.28U W=1U AS=0.5P AD=0.5P PS=3U PD=3U
M$380 MO5|MODOUT \$170 VSS VSS nfet_03v3 L=0.28U W=1U AS=0.5P AD=0.5P PS=3U
+ PD=3U
M$381 \$171 MO5|MODOUT VSS VSS nfet_03v3 L=0.28U W=1U AS=0.5P AD=0.5P PS=3U
+ PD=3U
M$382 \$170 \$165 \$171 VSS nfet_03v3 L=0.28U W=1U AS=0.5P AD=0.5P PS=3U PD=3U
M$383 NMI0 MO1|MODOUT VSS VSS nfet_03v3 L=0.28U W=1U AS=0.5P AD=0.5P PS=3U PD=3U
M$384 NMI0 SEL0 VSS VSS nfet_03v3 L=0.28U W=1U AS=0.5P AD=0.5P PS=3U PD=3U
M$385 MI0|MODIN NMI0 VSS VSS nfet_03v3 L=0.28U W=1U AS=0.5P AD=0.5P PS=3U PD=3U
M$386 NMI1 MO2|MODOUT VSS VSS nfet_03v3 L=0.28U W=1U AS=0.5P AD=0.5P PS=3U PD=3U
M$387 NMI1 SEL1 VSS VSS nfet_03v3 L=0.28U W=1U AS=0.5P AD=0.5P PS=3U PD=3U
M$388 MI1|MODIN NMI1 VSS VSS nfet_03v3 L=0.28U W=1U AS=0.5P AD=0.5P PS=3U PD=3U
M$389 NMI2 MO3|MODOUT VSS VSS nfet_03v3 L=0.28U W=1U AS=0.5P AD=0.5P PS=3U PD=3U
M$390 NMI2 SEL2 VSS VSS nfet_03v3 L=0.28U W=1U AS=0.5P AD=0.5P PS=3U PD=3U
M$391 MI2|MODIN NMI2 VSS VSS nfet_03v3 L=0.28U W=1U AS=0.5P AD=0.5P PS=3U PD=3U
M$392 NMI3 MO4|MODOUT VSS VSS nfet_03v3 L=0.28U W=1U AS=0.5P AD=0.5P PS=3U PD=3U
M$393 NMI3 SEL3 VSS VSS nfet_03v3 L=0.28U W=1U AS=0.5P AD=0.5P PS=3U PD=3U
M$394 MI3|MODIN NMI3 VSS VSS nfet_03v3 L=0.28U W=1U AS=0.5P AD=0.5P PS=3U PD=3U
M$395 NMI4 MO5|MODOUT VSS VSS nfet_03v3 L=0.28U W=1U AS=0.5P AD=0.5P PS=3U PD=3U
M$396 NMI4 SEL4 VSS VSS nfet_03v3 L=0.28U W=1U AS=0.5P AD=0.5P PS=3U PD=3U
M$397 MI4|MODIN NMI4 VSS VSS nfet_03v3 L=0.28U W=1U AS=0.5P AD=0.5P PS=3U PD=3U
M$398 XM0_NMID SEL0 VSS VSS nfet_03v3 L=0.28U W=2U AS=1P AD=1P PS=5U PD=5U
M$399 XM1_NMID SEL1 VSS VSS nfet_03v3 L=0.28U W=2U AS=1P AD=1P PS=5U PD=5U
M$400 XM2_NMID SEL2 VSS VSS nfet_03v3 L=0.28U W=2U AS=1P AD=1P PS=5U PD=5U
M$401 XM3_NMID SEL3 VSS VSS nfet_03v3 L=0.28U W=2U AS=1P AD=1P PS=5U PD=5U
M$402 XM4_NMID SEL4 VSS VSS nfet_03v3 L=0.28U W=2U AS=1P AD=1P PS=5U PD=5U
M$403 XM5_NMID MODIN|SEL5 VSS VSS nfet_03v3 L=0.28U W=2U AS=1P AD=1P PS=5U PD=5U
M$404 XMA_NM2 T2 VSS VSS nfet_03v3 L=0.28U W=3U AS=1.5P AD=1.5P PS=7U PD=7U
M$405 XMB_NM2 T5 VSS VSS nfet_03v3 L=0.28U W=3U AS=1.5P AD=1.5P PS=7U PD=7U
M$406 DIVOUTB MA VSS VSS nfet_03v3 L=0.28U W=1U AS=0.5P AD=0.5P PS=3U PD=3U
M$407 DIVOUTB MB VSS VSS nfet_03v3 L=0.28U W=1U AS=0.5P AD=0.5P PS=3U PD=3U
M$408 DIVOUT DIVOUTB VSS VSS nfet_03v3 L=0.28U W=2U AS=1P AD=1P PS=5U PD=5U
M$409 XFRT_CKB CKIN|VCO VSS VSS nfet_03v3 L=0.28U W=1U AS=0.5P AD=0.5P PS=3U
+ PD=3U
M$410 XFRT_CKBB XFRT_CKB VSS VSS nfet_03v3 L=0.28U W=1U AS=0.5P AD=0.5P PS=3U
+ PD=3U
M$411 XFRT_NM XFRT_CKB DIVOUT VSS nfet_03v3 L=0.28U W=1U AS=0.5P AD=0.5P PS=3U
+ PD=3U
M$412 XFRT_NMA XFRT_NM VSS VSS nfet_03v3 L=0.28U W=1U AS=0.5P AD=0.5P PS=3U
+ PD=3U
M$413 XFRT_NMB XFRT_NMA VSS VSS nfet_03v3 L=0.28U W=1U AS=0.5P AD=0.5P PS=3U
+ PD=3U
M$414 XFRT_NM XFRT_CKBB XFRT_NMB VSS nfet_03v3 L=0.28U W=1U AS=0.5P AD=0.5P
+ PS=3U PD=3U
M$415 XFRT_NS XFRT_CKBB XFRT_NMA VSS nfet_03v3 L=0.28U W=1U AS=0.5P AD=0.5P
+ PS=3U PD=3U
M$416 FB XFRT_NS VSS VSS nfet_03v3 L=0.28U W=1U AS=0.5P AD=0.5P PS=3U PD=3U
M$417 FBB FB VSS VSS nfet_03v3 L=0.28U W=1U AS=0.5P AD=0.5P PS=3U PD=3U
M$418 XFRT_NS XFRT_CKB FBB VSS nfet_03v3 L=0.28U W=1U AS=0.5P AD=0.5P PS=3U
+ PD=3U
M$419 \$17 P|P0 \$16 VSS nfet_03v3 L=0.28U W=3U AS=1.5P AD=1.5P PS=7U PD=7U
M$420 \$18 MI0|MODIN \$17 VSS nfet_03v3 L=0.28U W=3U AS=1.5P AD=1.5P PS=7U PD=7U
M$421 \$21 \$20 \$22 VSS nfet_03v3 L=0.28U W=2U AS=1P AD=1P PS=5U PD=5U
M$422 \$31 MI0|MODIN \$32 VSS nfet_03v3 L=0.28U W=2U AS=1P AD=1P PS=5U PD=5U
M$423 \$45 MI1|MODIN \$44 VSS nfet_03v3 L=0.28U W=3U AS=1.5P AD=1.5P PS=7U PD=7U
M$424 \$44 P|P1 \$43 VSS nfet_03v3 L=0.28U W=3U AS=1.5P AD=1.5P PS=7U PD=7U
M$425 \$48 \$46 \$47 VSS nfet_03v3 L=0.28U W=2U AS=1P AD=1P PS=5U PD=5U
M$426 \$58 MI1|MODIN \$57 VSS nfet_03v3 L=0.28U W=2U AS=1P AD=1P PS=5U PD=5U
M$427 \$69 P|P2 \$70 VSS nfet_03v3 L=0.28U W=3U AS=1.5P AD=1.5P PS=7U PD=7U
M$428 \$71 MI2|MODIN \$69 VSS nfet_03v3 L=0.28U W=3U AS=1.5P AD=1.5P PS=7U PD=7U
M$429 \$74 \$72 \$73 VSS nfet_03v3 L=0.28U W=2U AS=1P AD=1P PS=5U PD=5U
M$430 \$83 MI2|MODIN \$84 VSS nfet_03v3 L=0.28U W=2U AS=1P AD=1P PS=5U PD=5U
M$431 \$96 P|P3 \$95 VSS nfet_03v3 L=0.28U W=3U AS=1.5P AD=1.5P PS=7U PD=7U
M$432 \$97 MI3|MODIN \$96 VSS nfet_03v3 L=0.28U W=3U AS=1.5P AD=1.5P PS=7U PD=7U
M$433 \$100 \$98 \$99 VSS nfet_03v3 L=0.28U W=2U AS=1P AD=1P PS=5U PD=5U
M$434 \$109 MI3|MODIN \$110 VSS nfet_03v3 L=0.28U W=2U AS=1P AD=1P PS=5U PD=5U
M$435 \$122 P|P4 \$123 VSS nfet_03v3 L=0.28U W=3U AS=1.5P AD=1.5P PS=7U PD=7U
M$436 \$121 MI4|MODIN \$122 VSS nfet_03v3 L=0.28U W=3U AS=1.5P AD=1.5P PS=7U
+ PD=7U
M$437 \$126 \$124 \$125 VSS nfet_03v3 L=0.28U W=2U AS=1P AD=1P PS=5U PD=5U
M$438 \$135 MI4|MODIN \$136 VSS nfet_03v3 L=0.28U W=2U AS=1P AD=1P PS=5U PD=5U
M$439 \$148 MODIN|SEL5 \$149 VSS nfet_03v3 L=0.28U W=3U AS=1.5P AD=1.5P PS=7U
+ PD=7U
M$440 \$149 P|P5 \$147 VSS nfet_03v3 L=0.28U W=3U AS=1.5P AD=1.5P PS=7U PD=7U
M$441 \$151 \$150 \$152 VSS nfet_03v3 L=0.28U W=2U AS=1P AD=1P PS=5U PD=5U
M$442 \$163 MODIN|SEL5 \$162 VSS nfet_03v3 L=0.28U W=2U AS=1P AD=1P PS=5U PD=5U
M$443 T0 CK1|CKIN|CKOUT XM0_NMID VSS nfet_03v3 L=0.28U W=2U AS=1P AD=1P PS=5U
+ PD=5U
M$444 T1 CK2|CKIN|CKOUT XM1_NMID VSS nfet_03v3 L=0.28U W=2U AS=1P AD=1P PS=5U
+ PD=5U
M$445 T2 CK3|CKIN|CKOUT XM2_NMID VSS nfet_03v3 L=0.28U W=2U AS=1P AD=1P PS=5U
+ PD=5U
M$446 T3 CK4|CKIN|CKOUT XM3_NMID VSS nfet_03v3 L=0.28U W=2U AS=1P AD=1P PS=5U
+ PD=5U
M$447 T4 CK5|CKIN|CKOUT XM4_NMID VSS nfet_03v3 L=0.28U W=2U AS=1P AD=1P PS=5U
+ PD=5U
M$448 T5 CK6|CKOUT XM5_NMID VSS nfet_03v3 L=0.28U W=2U AS=1P AD=1P PS=5U PD=5U
M$449 XMA_NM1 T1 XMA_NM2 VSS nfet_03v3 L=0.28U W=3U AS=1.5P AD=1.5P PS=7U PD=7U
M$450 MA T0 XMA_NM1 VSS nfet_03v3 L=0.28U W=3U AS=1.5P AD=1.5P PS=7U PD=7U
M$451 MB T3 XMB_NM1 VSS nfet_03v3 L=0.28U W=3U AS=1.5P AD=1.5P PS=7U PD=7U
M$452 XMB_NM1 T4 XMB_NM2 VSS nfet_03v3 L=0.28U W=3U AS=1.5P AD=1.5P PS=7U PD=7U
.ENDS divider_chain
