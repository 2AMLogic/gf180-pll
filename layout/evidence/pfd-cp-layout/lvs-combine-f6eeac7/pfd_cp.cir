* Extracted by KLayout with GF180MCU LVS runset on : 17/11/2026 00:52

.SUBCKT pfd_cp
M$1 IBP IBP VDD VDD pfet_03v3 L=1U W=48U AS=24P AD=24P PS=97U PD=97U
M$2 ICP ICP VDD VDD pfet_03v3 L=1U W=12U AS=6P AD=6P PS=25U PD=25U
M$3 \$4 \$4 VDD VDD pfet_03v3 L=1U W=24U AS=12P AD=12P PS=49U PD=49U
M$4 \$5 \$4 VDD VDD pfet_03v3 L=1U W=24U AS=12P AD=12P PS=49U PD=49U
M$5 \$7 B0 VDD VDD pfet_03v3 L=0.3U W=1U AS=0.5P AD=0.5P PS=3U PD=3U
M$6 \$12 \$7 VDD VDD pfet_03v3 L=1U W=12U AS=6P AD=6P PS=25U PD=25U
M$7 \$8 B1 VDD VDD pfet_03v3 L=0.3U W=1U AS=0.5P AD=0.5P PS=3U PD=3U
M$8 \$13 \$8 VDD VDD pfet_03v3 L=1U W=12U AS=6P AD=6P PS=25U PD=25U
M$9 IBP \$9 \$7 VDD pfet_03v3 L=0.3U W=1U AS=0.5P AD=0.5P PS=3U PD=3U
M$10 IBP \$26 \$8 VDD pfet_03v3 L=0.3U W=1U AS=0.5P AD=0.5P PS=3U PD=3U
M$11 \$25 ICP \$12 VDD pfet_03v3 L=1U W=12U AS=6P AD=6P PS=25U PD=25U
M$12 \$25 ICP \$13 VDD pfet_03v3 L=1U W=12U AS=6P AD=6P PS=25U PD=25U
M$13 \$21 VDD VDD VDD pfet_03v3 L=0.3U W=1U AS=0.5P AD=0.5P PS=3U PD=3U
M$14 \$22 \$21 VDD VDD pfet_03v3 L=1U W=12U AS=6P AD=6P PS=25U PD=25U
M$15 IBP VSS \$21 VDD pfet_03v3 L=0.3U W=1U AS=0.5P AD=0.5P PS=3U PD=3U
M$16 \$25 ICP \$22 VDD pfet_03v3 L=1U W=12U AS=6P AD=6P PS=25U PD=25U
M$17 \$30 IBP VDD VDD pfet_03v3 L=1U W=48U AS=24P AD=24P PS=98U PD=98U
M$19 \$31 VOUT \$30 \$30 pfet_03v3 L=1U W=48U AS=24P AD=24P PS=98U PD=98U
M$20 \$5 \$5 \$30 \$30 pfet_03v3 L=1U W=48U AS=24P AD=24P PS=98U PD=98U
M$23 \$32 B1 VDD VDD pfet_03v3 L=0.3U W=1U AS=0.5P AD=0.5P PS=3U PD=3U
M$24 \$33 \$32 VDD VDD pfet_03v3 L=1U W=12U AS=6P AD=6P PS=25U PD=25U
M$25 IBP \$26 \$32 VDD pfet_03v3 L=0.3U W=1U AS=0.5P AD=0.5P PS=3U PD=3U
M$26 \$25 ICP \$33 VDD pfet_03v3 L=1U W=12U AS=6P AD=6P PS=25U PD=25U
M$27 \$25 \$53 VOUT VDD pfet_03v3 L=0.3U W=6U AS=3P AD=3P PS=13U PD=13U
M$28 \$25 UP \$5 VDD pfet_03v3 L=0.3U W=6U AS=3P AD=3P PS=13U PD=13U
M$29 VOUT UP VOUT VDD pfet_03v3 L=0.3U W=3U AS=1.5P AD=1.5P PS=7U PD=7U
M$30 \$44 REF VDD VDD pfet_03v3 L=0.3U W=1.5U AS=1.5P AD=1.5P PS=5U PD=5U
M$31 \$45 \$44 VDD VDD pfet_03v3 L=0.3U W=1.5U AS=1.5P AD=1.5P PS=5U PD=5U
M$32 \$46 \$45 VDD VDD pfet_03v3 L=0.3U W=1.5U AS=1.5P AD=1.5P PS=5U PD=5U
M$33 \$47 \$46 VDD VDD pfet_03v3 L=0.3U W=1.5U AS=1.5P AD=1.5P PS=5U PD=5U
M$34 \$48 \$47 VDD VDD pfet_03v3 L=0.3U W=1.5U AS=1.5P AD=1.5P PS=5U PD=5U
M$35 \$34 REF VDD VDD pfet_03v3 L=0.3U W=1.5U AS=1.5P AD=1.5P PS=5U PD=5U
M$36 VDD \$48 \$34 VDD pfet_03v3 L=0.3U W=1.5U AS=1.5P AD=1.5P PS=5U PD=5U
M$37 \$49 \$34 VDD VDD pfet_03v3 L=0.3U W=1.5U AS=1.5P AD=1.5P PS=5U PD=5U
M$38 \$50 \$49 VDD VDD pfet_03v3 L=0.3U W=1.5U AS=1.5P AD=1.5P PS=5U PD=5U
M$39 UP \$50 VDD VDD pfet_03v3 L=0.3U W=1.5U AS=1.5P AD=1.5P PS=5U PD=5U
M$40 VDD \$61 UP VDD pfet_03v3 L=0.3U W=1.5U AS=1.5P AD=1.5P PS=5U PD=5U
M$41 \$61 \$62 VDD VDD pfet_03v3 L=0.3U W=1.5U AS=1.5P AD=1.5P PS=5U PD=5U
M$42 VDD UP \$61 VDD pfet_03v3 L=0.3U W=1.5U AS=1.5P AD=1.5P PS=5U PD=5U
M$43 \$38 UP VDD VDD pfet_03v3 L=0.3U W=1.5U AS=1.5P AD=1.5P PS=5U PD=5U
M$44 VDD DN \$38 VDD pfet_03v3 L=0.3U W=1.5U AS=1.5P AD=1.5P PS=5U PD=5U
M$45 \$64 DN VDD VDD pfet_03v3 L=0.3U W=1.5U AS=1.5P AD=1.5P PS=5U PD=5U
M$46 VDD \$62 \$64 VDD pfet_03v3 L=0.3U W=1.5U AS=1.5P AD=1.5P PS=5U PD=5U
M$47 DN \$64 VDD VDD pfet_03v3 L=0.3U W=1.5U AS=1.5P AD=1.5P PS=5U PD=5U
M$48 VDD \$65 DN VDD pfet_03v3 L=0.3U W=1.5U AS=1.5P AD=1.5P PS=5U PD=5U
M$49 VDD \$55 \$65 VDD pfet_03v3 L=0.3U W=1.5U AS=1.5P AD=1.5P PS=5U PD=5U
M$50 VDD \$56 \$55 VDD pfet_03v3 L=0.3U W=1.5U AS=1.5P AD=1.5P PS=5U PD=5U
M$51 \$56 \$66 VDD VDD pfet_03v3 L=0.3U W=1.5U AS=1.5P AD=1.5P PS=5U PD=5U
M$52 VDD FB \$56 VDD pfet_03v3 L=0.3U W=1.5U AS=1.5P AD=1.5P PS=5U PD=5U
M$53 VDD \$57 \$66 VDD pfet_03v3 L=0.3U W=1.5U AS=1.5P AD=1.5P PS=5U PD=5U
M$54 VDD \$58 \$57 VDD pfet_03v3 L=0.3U W=1.5U AS=1.5P AD=1.5P PS=5U PD=5U
M$55 VDD \$59 \$58 VDD pfet_03v3 L=0.3U W=1.5U AS=1.5P AD=1.5P PS=5U PD=5U
M$56 VDD \$60 \$59 VDD pfet_03v3 L=0.3U W=1.5U AS=1.5P AD=1.5P PS=5U PD=5U
M$57 VDD FB \$60 VDD pfet_03v3 L=0.3U W=1.5U AS=1.5P AD=1.5P PS=5U PD=5U
M$58 VDD DN \$51 VDD pfet_03v3 L=0.3U W=1.5U AS=0.75P AD=0.75P PS=4U PD=4U
M$59 VDD UP \$53 VDD pfet_03v3 L=0.3U W=1.5U AS=0.75P AD=0.75P PS=4U PD=4U
M$60 VDD B0 \$9 VDD pfet_03v3 L=0.3U W=1.5U AS=0.75P AD=0.75P PS=4U PD=4U
M$61 VDD B1 \$26 VDD pfet_03v3 L=0.3U W=1.5U AS=0.75P AD=0.75P PS=4U PD=4U
M$62 \$72 \$38 VDD VDD pfet_03v3 L=0.3U W=1.5U AS=1.5P AD=1.5P PS=5U PD=5U
M$63 \$73 \$72 VDD VDD pfet_03v3 L=0.3U W=1.5U AS=1.5P AD=1.5P PS=5U PD=5U
M$64 \$74 \$73 VDD VDD pfet_03v3 L=0.3U W=1.5U AS=1.5P AD=1.5P PS=5U PD=5U
M$65 \$75 \$74 VDD VDD pfet_03v3 L=0.3U W=1.5U AS=1.5P AD=1.5P PS=5U PD=5U
M$66 \$76 \$75 VDD VDD pfet_03v3 L=0.3U W=1.5U AS=1.5P AD=1.5P PS=5U PD=5U
M$67 \$77 \$76 VDD VDD pfet_03v3 L=0.3U W=1.5U AS=1.5P AD=1.5P PS=5U PD=5U
M$68 \$78 \$77 VDD VDD pfet_03v3 L=0.3U W=1.5U AS=1.5P AD=1.5P PS=5U PD=5U
M$69 \$79 \$78 VDD VDD pfet_03v3 L=0.3U W=1.5U AS=1.5P AD=1.5P PS=5U PD=5U
M$70 \$80 \$79 VDD VDD pfet_03v3 L=0.3U W=1.5U AS=1.5P AD=1.5P PS=5U PD=5U
M$71 \$81 \$80 VDD VDD pfet_03v3 L=0.3U W=1.5U AS=1.5P AD=1.5P PS=5U PD=5U
M$72 \$82 \$81 VDD VDD pfet_03v3 L=0.3U W=1.5U AS=1.5P AD=1.5P PS=5U PD=5U
M$73 \$83 \$82 VDD VDD pfet_03v3 L=0.3U W=1.5U AS=1.5P AD=1.5P PS=5U PD=5U
M$74 \$84 \$83 VDD VDD pfet_03v3 L=0.3U W=1.5U AS=1.5P AD=1.5P PS=5U PD=5U
M$75 \$85 \$84 VDD VDD pfet_03v3 L=0.3U W=1.5U AS=1.5P AD=1.5P PS=5U PD=5U
M$76 \$86 \$85 VDD VDD pfet_03v3 L=0.3U W=1.5U AS=1.5P AD=1.5P PS=5U PD=5U
M$77 \$87 \$86 VDD VDD pfet_03v3 L=0.3U W=1.5U AS=1.5P AD=1.5P PS=5U PD=5U
M$78 \$88 \$87 VDD VDD pfet_03v3 L=0.3U W=1.5U AS=1.5P AD=1.5P PS=5U PD=5U
M$79 \$89 \$88 VDD VDD pfet_03v3 L=0.3U W=1.5U AS=1.5P AD=1.5P PS=5U PD=5U
M$80 \$90 \$89 VDD VDD pfet_03v3 L=0.3U W=1.5U AS=1.5P AD=1.5P PS=5U PD=5U
M$81 \$91 \$90 VDD VDD pfet_03v3 L=0.3U W=1.5U AS=1.5P AD=1.5P PS=5U PD=5U
M$82 \$92 \$91 VDD VDD pfet_03v3 L=0.3U W=1.5U AS=1.5P AD=1.5P PS=5U PD=5U
M$83 \$93 \$92 VDD VDD pfet_03v3 L=0.3U W=1.5U AS=1.5P AD=1.5P PS=5U PD=5U
M$84 \$94 \$93 VDD VDD pfet_03v3 L=0.3U W=1.5U AS=1.5P AD=1.5P PS=5U PD=5U
M$85 \$95 \$94 VDD VDD pfet_03v3 L=0.3U W=1.5U AS=1.5P AD=1.5P PS=5U PD=5U
M$86 \$96 \$95 VDD VDD pfet_03v3 L=0.3U W=1.5U AS=1.5P AD=1.5P PS=5U PD=5U
M$87 \$62 \$96 VDD VDD pfet_03v3 L=0.3U W=1.5U AS=1.5P AD=1.5P PS=5U PD=5U
M$88 \$3 IBN VSS VSS nfet_03v3 L=1U W=16U AS=8P AD=8P PS=33U PD=33U
M$89 \$4 VOUT \$3 VSS nfet_03v3 L=1U W=16U AS=8P AD=8P PS=33U PD=33U
M$90 \$5 \$5 \$3 VSS nfet_03v3 L=1U W=16U AS=8P AD=8P PS=33U PD=33U
M$91 IBN IBN VSS VSS nfet_03v3 L=1U W=16U AS=8P AD=8P PS=33U PD=33U
M$92 ICN ICN VSS VSS nfet_03v3 L=1U W=4U AS=2P AD=2P PS=9U PD=9U
M$93 \$10 \$9 VSS VSS nfet_03v3 L=0.3U W=1U AS=0.5P AD=0.5P PS=3U PD=3U
M$94 \$14 \$10 VSS VSS nfet_03v3 L=1U W=4U AS=2P AD=2P PS=9U PD=9U
M$95 \$11 \$26 VSS VSS nfet_03v3 L=0.3U W=1U AS=0.5P AD=0.5P PS=3U PD=3U
M$96 \$15 \$11 VSS VSS nfet_03v3 L=1U W=4U AS=2P AD=2P PS=9U PD=9U
M$97 IBN B0 \$10 VSS nfet_03v3 L=0.3U W=1U AS=0.5P AD=0.5P PS=3U PD=3U
M$98 IBN B1 \$11 VSS nfet_03v3 L=0.3U W=1U AS=0.5P AD=0.5P PS=3U PD=3U
M$99 \$23 ICN \$14 VSS nfet_03v3 L=1U W=4U AS=2P AD=2P PS=9U PD=9U
M$100 \$23 ICN \$15 VSS nfet_03v3 L=1U W=4U AS=2P AD=2P PS=9U PD=9U
M$101 \$19 VSS VSS VSS nfet_03v3 L=0.3U W=1U AS=0.5P AD=0.5P PS=3U PD=3U
M$102 IBN VDD \$19 VSS nfet_03v3 L=0.3U W=1U AS=0.5P AD=0.5P PS=3U PD=3U
M$103 \$20 \$19 VSS VSS nfet_03v3 L=1U W=4U AS=2P AD=2P PS=9U PD=9U
M$104 \$23 ICN \$20 VSS nfet_03v3 L=1U W=4U AS=2P AD=2P PS=9U PD=9U
M$105 \$28 \$26 VSS VSS nfet_03v3 L=0.3U W=1U AS=0.5P AD=0.5P PS=3U PD=3U
M$106 \$29 \$28 VSS VSS nfet_03v3 L=1U W=4U AS=2P AD=2P PS=9U PD=9U
M$107 \$31 \$31 VSS VSS nfet_03v3 L=1U W=16U AS=8P AD=8P PS=33U PD=33U
M$108 \$5 \$31 VSS VSS nfet_03v3 L=1U W=16U AS=8P AD=8P PS=33U PD=33U
M$109 IBN B1 \$28 VSS nfet_03v3 L=0.3U W=1U AS=0.5P AD=0.5P PS=3U PD=3U
M$110 \$23 ICN \$29 VSS nfet_03v3 L=1U W=4U AS=2P AD=2P PS=9U PD=9U
M$111 \$35 REF \$34 VSS nfet_03v3 L=0.3U W=1U AS=1P AD=1P PS=4U PD=4U
M$112 VSS \$48 \$35 VSS nfet_03v3 L=0.3U W=1U AS=1P AD=1P PS=4U PD=4U
M$113 \$36 \$50 UP VSS nfet_03v3 L=0.3U W=1U AS=1P AD=1P PS=4U PD=4U
M$114 VSS \$61 \$36 VSS nfet_03v3 L=0.3U W=1U AS=1P AD=1P PS=4U PD=4U
M$115 \$37 \$62 \$61 VSS nfet_03v3 L=0.3U W=1U AS=1P AD=1P PS=4U PD=4U
M$116 VSS UP \$37 VSS nfet_03v3 L=0.3U W=1U AS=1P AD=1P PS=4U PD=4U
M$117 \$39 UP \$38 VSS nfet_03v3 L=0.3U W=1U AS=1P AD=1P PS=4U PD=4U
M$118 VSS DN \$39 VSS nfet_03v3 L=0.3U W=1U AS=1P AD=1P PS=4U PD=4U
M$119 \$40 DN VSS VSS nfet_03v3 L=0.3U W=1U AS=1P AD=1P PS=4U PD=4U
M$120 \$64 \$62 \$40 VSS nfet_03v3 L=0.3U W=1U AS=1P AD=1P PS=4U PD=4U
M$121 \$41 \$64 VSS VSS nfet_03v3 L=0.3U W=1U AS=1P AD=1P PS=4U PD=4U
M$122 DN \$65 \$41 VSS nfet_03v3 L=0.3U W=1U AS=1P AD=1P PS=4U PD=4U
M$123 \$42 \$66 VSS VSS nfet_03v3 L=0.3U W=1U AS=1P AD=1P PS=4U PD=4U
M$124 \$56 FB \$42 VSS nfet_03v3 L=0.3U W=1U AS=1P AD=1P PS=4U PD=4U
M$125 \$44 REF VSS VSS nfet_03v3 L=0.3U W=0.5U AS=0.5P AD=0.5P PS=3U PD=3U
M$126 \$45 \$44 VSS VSS nfet_03v3 L=0.3U W=0.5U AS=0.5P AD=0.5P PS=3U PD=3U
M$127 \$46 \$45 VSS VSS nfet_03v3 L=0.3U W=0.5U AS=0.5P AD=0.5P PS=3U PD=3U
M$128 \$47 \$46 VSS VSS nfet_03v3 L=0.3U W=0.5U AS=0.5P AD=0.5P PS=3U PD=3U
M$129 \$48 \$47 VSS VSS nfet_03v3 L=0.3U W=0.5U AS=0.5P AD=0.5P PS=3U PD=3U
M$130 \$49 \$34 VSS VSS nfet_03v3 L=0.3U W=0.5U AS=0.5P AD=0.5P PS=3U PD=3U
M$131 \$50 \$49 VSS VSS nfet_03v3 L=0.3U W=0.5U AS=0.5P AD=0.5P PS=3U PD=3U
M$132 VSS \$55 \$65 VSS nfet_03v3 L=0.3U W=0.5U AS=0.5P AD=0.5P PS=3U PD=3U
M$133 VSS \$56 \$55 VSS nfet_03v3 L=0.3U W=0.5U AS=0.5P AD=0.5P PS=3U PD=3U
M$134 VSS \$57 \$66 VSS nfet_03v3 L=0.3U W=0.5U AS=0.5P AD=0.5P PS=3U PD=3U
M$135 VSS \$58 \$57 VSS nfet_03v3 L=0.3U W=0.5U AS=0.5P AD=0.5P PS=3U PD=3U
M$136 VSS \$59 \$58 VSS nfet_03v3 L=0.3U W=0.5U AS=0.5P AD=0.5P PS=3U PD=3U
M$137 VSS \$60 \$59 VSS nfet_03v3 L=0.3U W=0.5U AS=0.5P AD=0.5P PS=3U PD=3U
M$138 VSS FB \$60 VSS nfet_03v3 L=0.3U W=0.5U AS=0.5P AD=0.5P PS=3U PD=3U
M$139 \$51 DN VSS VSS nfet_03v3 L=0.3U W=0.5U AS=0.25P AD=0.25P PS=2U PD=2U
M$140 VOUT DN \$23 VSS nfet_03v3 L=0.3U W=6U AS=3P AD=3P PS=13U PD=13U
M$141 \$5 \$51 \$23 VSS nfet_03v3 L=0.3U W=6U AS=3P AD=3P PS=13U PD=13U
M$142 VOUT \$51 VOUT VSS nfet_03v3 L=0.3U W=3U AS=1.5P AD=1.5P PS=7U PD=7U
M$143 \$53 UP VSS VSS nfet_03v3 L=0.3U W=0.5U AS=0.25P AD=0.25P PS=2U PD=2U
M$144 \$9 B0 VSS VSS nfet_03v3 L=0.3U W=0.5U AS=0.25P AD=0.25P PS=2U PD=2U
M$145 \$26 B1 VSS VSS nfet_03v3 L=0.3U W=0.5U AS=0.25P AD=0.25P PS=2U PD=2U
M$146 \$72 \$38 VSS VSS nfet_03v3 L=0.3U W=0.5U AS=0.5P AD=0.5P PS=3U PD=3U
M$147 \$73 \$72 VSS VSS nfet_03v3 L=0.3U W=0.5U AS=0.5P AD=0.5P PS=3U PD=3U
M$148 \$74 \$73 VSS VSS nfet_03v3 L=0.3U W=0.5U AS=0.5P AD=0.5P PS=3U PD=3U
M$149 \$75 \$74 VSS VSS nfet_03v3 L=0.3U W=0.5U AS=0.5P AD=0.5P PS=3U PD=3U
M$150 \$76 \$75 VSS VSS nfet_03v3 L=0.3U W=0.5U AS=0.5P AD=0.5P PS=3U PD=3U
M$151 \$77 \$76 VSS VSS nfet_03v3 L=0.3U W=0.5U AS=0.5P AD=0.5P PS=3U PD=3U
M$152 \$78 \$77 VSS VSS nfet_03v3 L=0.3U W=0.5U AS=0.5P AD=0.5P PS=3U PD=3U
M$153 \$79 \$78 VSS VSS nfet_03v3 L=0.3U W=0.5U AS=0.5P AD=0.5P PS=3U PD=3U
M$154 \$80 \$79 VSS VSS nfet_03v3 L=0.3U W=0.5U AS=0.5P AD=0.5P PS=3U PD=3U
M$155 \$81 \$80 VSS VSS nfet_03v3 L=0.3U W=0.5U AS=0.5P AD=0.5P PS=3U PD=3U
M$156 \$82 \$81 VSS VSS nfet_03v3 L=0.3U W=0.5U AS=0.5P AD=0.5P PS=3U PD=3U
M$157 \$83 \$82 VSS VSS nfet_03v3 L=0.3U W=0.5U AS=0.5P AD=0.5P PS=3U PD=3U
M$158 \$84 \$83 VSS VSS nfet_03v3 L=0.3U W=0.5U AS=0.5P AD=0.5P PS=3U PD=3U
M$159 \$85 \$84 VSS VSS nfet_03v3 L=0.3U W=0.5U AS=0.5P AD=0.5P PS=3U PD=3U
M$160 \$86 \$85 VSS VSS nfet_03v3 L=0.3U W=0.5U AS=0.5P AD=0.5P PS=3U PD=3U
M$161 \$87 \$86 VSS VSS nfet_03v3 L=0.3U W=0.5U AS=0.5P AD=0.5P PS=3U PD=3U
M$162 \$88 \$87 VSS VSS nfet_03v3 L=0.3U W=0.5U AS=0.5P AD=0.5P PS=3U PD=3U
M$163 \$89 \$88 VSS VSS nfet_03v3 L=0.3U W=0.5U AS=0.5P AD=0.5P PS=3U PD=3U
M$164 \$90 \$89 VSS VSS nfet_03v3 L=0.3U W=0.5U AS=0.5P AD=0.5P PS=3U PD=3U
M$165 \$91 \$90 VSS VSS nfet_03v3 L=0.3U W=0.5U AS=0.5P AD=0.5P PS=3U PD=3U
M$166 \$92 \$91 VSS VSS nfet_03v3 L=0.3U W=0.5U AS=0.5P AD=0.5P PS=3U PD=3U
M$167 \$93 \$92 VSS VSS nfet_03v3 L=0.3U W=0.5U AS=0.5P AD=0.5P PS=3U PD=3U
M$168 \$94 \$93 VSS VSS nfet_03v3 L=0.3U W=0.5U AS=0.5P AD=0.5P PS=3U PD=3U
M$169 \$95 \$94 VSS VSS nfet_03v3 L=0.3U W=0.5U AS=0.5P AD=0.5P PS=3U PD=3U
M$170 \$96 \$95 VSS VSS nfet_03v3 L=0.3U W=0.5U AS=0.5P AD=0.5P PS=3U PD=3U
M$171 \$62 \$96 VSS VSS nfet_03v3 L=0.3U W=0.5U AS=0.5P AD=0.5P PS=3U PD=3U
.ENDS pfd_cp
