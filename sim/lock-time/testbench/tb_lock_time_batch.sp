* gf180-pll :: lock-time :: closed-loop lock-acquisition testbench (#12)
*
* DUT: `pll_top` -- the whole PLL, from design/pll_top.sch, netlisted by
* design/netlist.sh into design/netlist/pll_top.spice and prepended to this
* fragment by sim/lib/pll_top_dut.sh (#52).  Nothing here re-implements any
* block behaviourally, and -- since #159 -- nothing here wires the loop
* either: the instance line below is generated by that helper's
* `cloop_instance`, so a change to the loop's connectivity is a schematic
* diff rather than a silent divergence between two campaigns' hand-written
* instance lists.
*
* MIGRATED FROM sim/lib/assemble_closed_loop.sh (#159).  Until #159 this deck
* included a concatenation of the five block exports and wired vco/pfd_cp/
* loop_filter/divider_chain/lock_detector together itself.  Every record in
* sim/lock-time/records/ predating that migration was taken against that
* older DUT and says so in its own Netlist provenance field; those records
* are append-only evidence and are not restated or reinterpreted here.  What
* changed, precisely:
*   - the loop's top-level wiring now comes from design/pll_top.sch;
*   - the VCO's ground is pll_top's own GND_VCO domain (driven to 0 V by its
*     own source below) rather than being shorted to VSS in the testbench --
*     electrically the same node voltage, but it makes the VCO's supply
*     current separately observable, as pll-top-smoke and supply-sensitivity
*     already have it;
*   - the static configuration bits arrive as `*_code` params encoded by
*     sim/lib/pll_top_dut.sh's cloop_band_params / cloop_trim_params /
*     cloop_divider_params, rather than as pre-multiplied `*v` voltages
*     computed in run.sh.  A mis-encoded one-hot SEL code still locks, just
*     at the wrong N, which is exactly the class of error a single owner of
*     the encoding exists to prevent.
*
* Topology (net names below are pll_top's own port names, lowercased):
*   ref    -- external reference clock, frequency 'fref'
*   fb     -- divider's retimed feedback edge, back into the PFD
*   vctrl  -- the ONE control node: PFD/CP's VOUT = loop filter's VCTRL pin =
*             VCO's VCTRL pin (the filter is a pure shunt network to ground,
*             per design/README.md's block diagram)
*   clk    -- VCO output; divout -- divider output; lock -- the design's own
*             lock_detector output (#11), the lock criterion this bench reads
*   xdut.up / xdut.dn / xdut.vwin -- PFD outputs and the detector's window
*             node, now INTERNAL to pll_top and referenced hierarchically
*
* Expects from the generated header (sim/lib/simenv.sh):
*   .lib <corner> / .temp <temp_c> / .param vsup=<V>
*   .param fref=<reference Hz>
*   .param b0_code b1_code b2_code    VCO band-select bits      (0 or 1)
*   .param cpb0_code cpb1_code        PFD/CP Icp-trim bits      (0 or 1)
*   .param sel0_code..sel5_code       divider chain-length bits (0 or 1)
*   .param p0_code..p5_code           divider modulus bits      (0 or 1)
*   .param iunit=<A>                 CP bias reference unit current
*   .param vctrl_ic=<V>              initial condition on the control node --
*                                    0.9 or 2.7 (the usable-window rails) picks
*                                    cold-start vs. worst-case re-lock (see
*                                    run.sh); applied via a released clamp,
*                                    not a bare .ic (see below)
*   .param t_force=<s>               how long the vctrl_ic clamp holds after
*                                    t=0 before releasing (run.sh: a small
*                                    fraction of one reference period)
*   .param tstop tstep               transient window / print step, sized per N
*                                    in run.sh
*   .param tmax=<s>                  ceiling on the ngspice INTERNAL timestep
*                                    (.tran's 4th argument). Required, not
*                                    optional: run.sh passes
*                                    SIMENV_CLOSED_LOOP_TMAX. See the .tran
*                                    card below.
*   .param lockthresh=<V>            LOCK digital threshold (0.5*vsup)

*------------------------------------------------------------------ supplies
vvdd    vdd     0 dc 'vdd_val'
vvddvco vdd_vco 0 dc 'vdd_val'
vvdddiv vdd_div 0 dc 'vdd_val'
vgndvco gnd_vco 0 dc 0
vvss    vss     0 dc 0

*----------------------------------------------------------- reference clock
* 200 ps edges (not ideal steps) -- consistent with pfd-deadzone's stimulus,
* so this deck does not flatter the PFD's reset-path delay.
vref ref 0 pulse(0 'vdd_val' 20n 200p 200p '0.5/fref-200p' '1/fref')

*----------------------------------------------------- static configuration
* Every one of these is a real pin on pll_top: DR-001 Decision 2 keeps band
* select a static input with no calibration FSM, and Decision 3 does the same
* for N.  The `*_code` values are 0/1 and are encoded by
* sim/lib/pll_top_dut.sh, not by this deck.
vb0   b0   0 dc 'vdd_val*b0_code'
vb1   b1   0 dc 'vdd_val*b1_code'
vb2   b2   0 dc 'vdd_val*b2_code'
vcpb0 cpb0 0 dc 'vdd_val*cpb0_code'
vcpb1 cpb1 0 dc 'vdd_val*cpb1_code'

* Lock-detector window trim (DR-014, #411): a 4-bit STATIC process trim,
* set once at test and held for the life of the part, so it is a DC source
* like the band and Icp codes beside it and never changes inside a run.
* The code this deck runs at comes from the campaign's own runner/manifest
* (sim/lib/pll_top_dut.sh's cloop_window_trim_params), not from here.
vldt0 ldt0 0 dc 'vdd_val*ldt0_code'
vldt1 ldt1 0 dc 'vdd_val*ldt1_code'
vldt2 ldt2 0 dc 'vdd_val*ldt2_code'
vldt3 ldt3 0 dc 'vdd_val*ldt3_code'

vp0   p0   0 dc 'vdd_val*p0_code'
vp1   p1   0 dc 'vdd_val*p1_code'
vp2   p2   0 dc 'vdd_val*p2_code'
vp3   p3   0 dc 'vdd_val*p3_code'
vp4   p4   0 dc 'vdd_val*p4_code'
vp5   p5   0 dc 'vdd_val*p5_code'
vs0   sel0 0 dc 'vdd_val*sel0_code'
vs1   sel1 0 dc 'vdd_val*sel1_code'
vs2   sel2 0 dc 'vdd_val*sel2_code'
vs3   sel3 0 dc 'vdd_val*sel3_code'
vs4   sel4 0 dc 'vdd_val*sel4_code'
vs5   sel5 0 dc 'vdd_val*sel5_code'

* Charge-pump bias reference -- ideal current sources at 4x the unit-leg
* current, exactly as sim/devchar-cp / sim/pfd-deadzone / sim/cp-compliance
* drive the same four nodes (bias generation is out of scope for cp.sch,
* see design/README.md).
iibn vdd ibn dc 'iunit'
iicn vdd icn dc 'iunit'
iibp ibp 0 dc 'iunit'
iicp icp 0 dc 'iunit'

*--------------------------------------------------------------------- DUT
* Generated by sim/lib/pll_top_dut.sh's `cloop_instance`, so the 36-port
* order is never transcribed by hand in a campaign.
xdut ref b0 b1 b2 cpb0 cpb1 ldt0 ldt1 ldt2 ldt3 p0 p1 p2 p3 p4 p5 sel0 sel1 sel2 sel3 sel4 sel5
+ ibn icn ibp icp clk divout fb lock vctrl vdd vdd_vco gnd_vco vdd_div vss
+ pll_top

* Break the ring's DC symmetry (see sim/vco-tuning-range/testbench/tb_vco_tuning.sp
* for the same technique and why `uic` is deliberately NOT used: the bias
* generator must settle to its own operating point before t=0).  The ring
* nodes are now one level deeper in the hierarchy than they were before #159.
.ic v(xdut.xvco.y1)=0 v(xdut.xvco.y2)='vdd_val' v(xdut.xvco.y3)=0
+ v(xdut.xvco.y4)='vdd_val' v(xdut.xvco.y5)=0

* Control-node initial condition, WITHOUT `uic`. Vctrl has a well-determined
* DC operating point (it is DC-connected through the charge pump's output
* impedance and the filter's own resistor to ground), so a bare `.ic v(vctrl)`
* would only seed the op-point solver's Newton iteration and NOT survive into
* the transient -- op always converges to the same node voltage regardless of
* the seed. A hard, released clamp is used instead: a voltage-controlled
* switch ties VCTRL to 'vctrl_ic' through a low Ron for the op solve and the
* first 't_force' of the transient, then opens (Roff) and the loop runs
* freely from there. 'vctrl_ic' = 0.9 V (bottom of the usable window) selects
* cold start; 2.7 V (top) selects worst-case re-lock -- the largest excursion
* the loop could ever have to recover from, upper-bounding any real
* disturbance (reference retune within the band, supply glitch, coarse-band
* change) with a smaller one. See run.sh and this record's Methodology field.
* VCTRL is a pll_top PORT, so the clamp still attaches at the top level
* exactly as it did before #159.
vsetv vsetnode 0 dc 'vctrl_ic'
* Release transition sized as a multiple of the internal-timestep ceiling
* (#65), not a hardcoded constant -- see this campaign's investigation record
* for why: at the OLD 100 ps tr/tf (equal to #65's own 100 ps ceiling), the
* switch's Ron(10)/Roff(1G) discontinuity spans exactly one ceiling-sized
* step, which ngspice cannot resolve (LTE drives the internal step below its
* numerical floor -- "Timestep too small" -- 100% reproducible at vctrl_ic=
* 0.9V, independent of corner or host load). Ten ceiling-steps across the
* transition (10*tmax) gives the integrator enough resolution to follow it;
* tying it to 'tmax' rather than a fixed constant keeps it proportionate if
* SIM_TMAX is ever overridden for a controlled sub-experiment.
vsctrl sctrl 0 pulse('vdd_val' 0 't_force' '10*tmax' '10*tmax' '2*tstop' '4*tstop')
sforce vctrl vsetnode sctrl 0 SWFORCE
.model SWFORCE SW(Ron=10 Roff=1G Vt='vdd_val/2' Vh=0)

* rshunt / itl4 are REQUIRED on this DUT, and they are solver knobs only --
* every convergence TOLERANCE below is this campaign's own, unchanged from
* before #159, so the converged solution is the same one this campaign has
* always reported.
*
* rshunt: the charge pump's disabled trim legs leave their cascode mid-node
* driven only by two off devices -- a floating node for the DC operating
* point.  Same 1 Tohm shunt sim/pfd-deadzone, sim/pll-top-smoke and
* sim/supply-sensitivity use, for the same reason; at 3.3 V it is 3.3 pA
* against a multi-microamp signal.  It is not optional here: without it, the
* migrated deck aborts with "Timestep too small ... trouble with node
* e.xdut.xlf.xcf4.ec_moscap#branch" at t = 1.39 ns -- inside the SWFORCE
* release ramp, on the loop filter's nonlinear moscap branch -- at
* typical/27C/3.30V, reproducibly, on ngspice-46.  Verified by bisection
* against the pre-#159 deck at that same point: rshunt alone is what fixes
* it (the control-block transient and the `save` list below are not
* implicated), and with it the migrated deck reproduces the pre-migration
* deck's own numbers at that point to five significant figures
* (vctrl_final 9.36878e-01 V vs 9.36869e-01 V; dn_lvl 1.47686e-05 V vs
* 1.47747e-05 V, 100 ns window).
* itl4: transient Newton-iteration limit, a solver-EFFORT knob, carried at
* sim/pll-top-smoke's value because this campaign sweeps 45 corners where
* that campaign runs one.  rshunt alone was sufficient at the smoke point;
* itl4 buys iteration headroom without touching a tolerance.

* The transient is issued from the `.control` block at the bottom, NOT from a
* top-level `.tran` card, and that is load-bearing rather than stylistic.
* With BOTH present -- which is how this deck stood before #159 -- ngspice
* batch mode runs the control block's analysis and then runs the top-level
* card AGAIN: two full transients, double the wall clock, for one record.
* sim/pll-top-smoke/testbench/tb_pll_smoke.sp documented that behaviour; the
* records this campaign minted before #159 report the same observation from
* the other end, as "ngspice printed a complete set of measurements and THEN
* re-entered its own analysis path a second time before exiting (observed,
* not fully root-caused)".  It is the same effect, and dropping the top-level
* card is the fix.  The `.meas` cards below still evaluate against the
* control block's run (measurements attach to the analysis, not to the card
* that launched it), so this deck keeps the readable top-level `.meas` style
* every other campaign here uses.  `.csparam` is how the .param values reach
* the control block, the same mechanism sim/pfd-deadzone uses for `vsup`.
*
* The 4th tran argument (tmax) is LOAD-BEARING, not decoration: it is the
* ceiling on the ngspice INTERNAL timestep, set by the PFD's internal SR-latch
* set pulse (0.33-0.39 ns) and NOT by f_out. Omitting it -- as this deck did
* until #65 -- makes ngspice default the internal ceiling to the print step
* {tstep}, which run.sh sizes as 1/(50*f_out): 250 ps at this campaign's fixed
* 80 MHz target, coarse enough that the integrator runs pinned at the ceiling
* (measured mean internal step 0.230 ns) with barely one step inside the set
* pulse. See sim/lib/simenv.sh's SIMENV_CLOSED_LOOP_TMAX and sim/README.md's
* "Closed-loop internal-timestep bound" for why that misreports a locked loop
* as jammed-with-UP.
* BATCH-MANIFEST PORT (#828).  Everything above is tb_lock_time.sp unchanged
* except that `vsup` is the harness's `vdd_val`, and that the solver options,
* the transient (`tran {tstep} {tstop} 0 {tmax}`) and the four measurements
* (t_lock_last_rise, lock_at_end, vctrl_final, dn_lvl) are declared in tb.json
* rather than as .options/.control/.measure here, because the harness owns
* those directives.  The lock threshold `lockthresh` is vdd_val/2 there.
