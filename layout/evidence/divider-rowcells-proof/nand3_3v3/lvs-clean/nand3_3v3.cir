* Extracted by KLayout with GF180MCU LVS runset on : 09/09/2026 01:18

.SUBCKT nand3_3v3 VSS C B A Y VDD
M$1 VDD C Y VDD pfet_03v3 L=0.28U W=2.5U AS=1.25P AD=1.25P PS=6U PD=6U
M$2 VDD B Y VDD pfet_03v3 L=0.28U W=2.5U AS=1.25P AD=1.25P PS=6U PD=6U
M$3 VDD A Y VDD pfet_03v3 L=0.28U W=2.5U AS=1.25P AD=1.25P PS=6U PD=6U
M$4 Y A \$7 VSS nfet_03v3 L=0.28U W=3U AS=1.5P AD=1.5P PS=7U PD=7U
M$5 \$7 B \$4 VSS nfet_03v3 L=0.28U W=3U AS=1.5P AD=1.5P PS=7U PD=7U
M$6 \$4 C VSS VSS nfet_03v3 L=0.28U W=3U AS=1.5P AD=1.5P PS=7U PD=7U
.ENDS nand3_3v3
