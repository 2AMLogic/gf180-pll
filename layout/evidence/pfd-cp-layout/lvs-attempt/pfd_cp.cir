* Extracted by KLayout with GF180MCU LVS runset on : 21/09/2026 10:56

.SUBCKT pfd_cp IBP|VBP VDUMP REF IBN|VBN ENB|VSS DN|UP DN FB UP B0B|ENB B0|EN
+ EN|VDD DNT|TAIL ICN|VCASCN ICP|VCASCP TAIL|UPT B1B|ENB B1|EN VOUT|VREF VSS
M$1 IBP|VBP IBP|VBP EN|VDD EN|VDD pfet_03v3 L=1U W=48U AS=24P AD=24P PS=97U
+ PD=97U
M$2 ICP|VCASCP ICP|VCASCP EN|VDD EN|VDD pfet_03v3 L=1U W=12U AS=6P AD=6P PS=25U
+ PD=25U
M$3 \$4 \$4 EN|VDD EN|VDD pfet_03v3 L=1U W=24U AS=12P AD=12P PS=49U PD=49U
M$4 VDUMP \$4 EN|VDD EN|VDD pfet_03v3 L=1U W=24U AS=12P AD=12P PS=49U PD=49U
M$5 \$15 REF EN|VDD EN|VDD pfet_03v3 L=0.3U W=1.5U AS=1.5P AD=1.5P PS=5U PD=5U
M$6 \$16 \$15 EN|VDD EN|VDD pfet_03v3 L=0.3U W=1.5U AS=1.5P AD=1.5P PS=5U PD=5U
M$7 \$17 \$16 EN|VDD EN|VDD pfet_03v3 L=0.3U W=1.5U AS=1.5P AD=1.5P PS=5U PD=5U
M$8 \$18 \$17 EN|VDD EN|VDD pfet_03v3 L=0.3U W=1.5U AS=1.5P AD=1.5P PS=5U PD=5U
M$9 \$19 \$18 EN|VDD EN|VDD pfet_03v3 L=0.3U W=1.5U AS=1.5P AD=1.5P PS=5U PD=5U
M$10 \$20 REF EN|VDD EN|VDD pfet_03v3 L=0.3U W=1.5U AS=1.5P AD=1.5P PS=5U PD=5U
M$11 EN|VDD \$19 \$20 EN|VDD pfet_03v3 L=0.3U W=1.5U AS=1.5P AD=1.5P PS=5U PD=5U
M$12 \$22 \$20 EN|VDD EN|VDD pfet_03v3 L=0.3U W=1.5U AS=1.5P AD=1.5P PS=5U PD=5U
M$13 \$23 \$22 EN|VDD EN|VDD pfet_03v3 L=0.3U W=1.5U AS=1.5P AD=1.5P PS=5U PD=5U
M$14 UP \$23 EN|VDD EN|VDD pfet_03v3 L=0.3U W=1.5U AS=1.5P AD=1.5P PS=5U PD=5U
M$15 EN|VDD \$74 UP EN|VDD pfet_03v3 L=0.3U W=1.5U AS=1.5P AD=1.5P PS=5U PD=5U
M$16 \$74 DN|UP EN|VDD EN|VDD pfet_03v3 L=0.3U W=1.5U AS=1.5P AD=1.5P PS=5U
+ PD=5U
M$17 EN|VDD UP \$74 EN|VDD pfet_03v3 L=0.3U W=1.5U AS=1.5P AD=1.5P PS=5U PD=5U
M$18 \$26 UP EN|VDD EN|VDD pfet_03v3 L=0.3U W=1.5U AS=1.5P AD=1.5P PS=5U PD=5U
M$19 EN|VDD DN \$26 EN|VDD pfet_03v3 L=0.3U W=1.5U AS=1.5P AD=1.5P PS=5U PD=5U
M$20 \$77 DN EN|VDD EN|VDD pfet_03v3 L=0.3U W=1.5U AS=1.5P AD=1.5P PS=5U PD=5U
M$21 EN|VDD DN|UP \$77 EN|VDD pfet_03v3 L=0.3U W=1.5U AS=1.5P AD=1.5P PS=5U
+ PD=5U
M$22 DN \$77 EN|VDD EN|VDD pfet_03v3 L=0.3U W=1.5U AS=1.5P AD=1.5P PS=5U PD=5U
M$23 EN|VDD \$78 DN EN|VDD pfet_03v3 L=0.3U W=1.5U AS=1.5P AD=1.5P PS=5U PD=5U
M$24 EN|VDD \$30 \$78 EN|VDD pfet_03v3 L=0.3U W=1.5U AS=1.5P AD=1.5P PS=5U PD=5U
M$25 EN|VDD \$31 \$30 EN|VDD pfet_03v3 L=0.3U W=1.5U AS=1.5P AD=1.5P PS=5U PD=5U
M$26 \$31 \$79 EN|VDD EN|VDD pfet_03v3 L=0.3U W=1.5U AS=1.5P AD=1.5P PS=5U PD=5U
M$27 EN|VDD FB \$31 EN|VDD pfet_03v3 L=0.3U W=1.5U AS=1.5P AD=1.5P PS=5U PD=5U
M$28 EN|VDD \$33 \$79 EN|VDD pfet_03v3 L=0.3U W=1.5U AS=1.5P AD=1.5P PS=5U PD=5U
M$29 EN|VDD \$34 \$33 EN|VDD pfet_03v3 L=0.3U W=1.5U AS=1.5P AD=1.5P PS=5U PD=5U
M$30 EN|VDD \$35 \$34 EN|VDD pfet_03v3 L=0.3U W=1.5U AS=1.5P AD=1.5P PS=5U PD=5U
M$31 EN|VDD \$36 \$35 EN|VDD pfet_03v3 L=0.3U W=1.5U AS=1.5P AD=1.5P PS=5U PD=5U
M$32 EN|VDD FB \$36 EN|VDD pfet_03v3 L=0.3U W=1.5U AS=1.5P AD=1.5P PS=5U PD=5U
M$33 \$175 \$26 EN|VDD EN|VDD pfet_03v3 L=0.3U W=1.5U AS=1.5P AD=1.5P PS=5U
+ PD=5U
M$34 \$176 \$175 EN|VDD EN|VDD pfet_03v3 L=0.3U W=1.5U AS=1.5P AD=1.5P PS=5U
+ PD=5U
M$35 \$177 \$176 EN|VDD EN|VDD pfet_03v3 L=0.3U W=1.5U AS=1.5P AD=1.5P PS=5U
+ PD=5U
M$36 \$178 \$177 EN|VDD EN|VDD pfet_03v3 L=0.3U W=1.5U AS=1.5P AD=1.5P PS=5U
+ PD=5U
M$37 \$179 \$178 EN|VDD EN|VDD pfet_03v3 L=0.3U W=1.5U AS=1.5P AD=1.5P PS=5U
+ PD=5U
M$38 \$180 \$179 EN|VDD EN|VDD pfet_03v3 L=0.3U W=1.5U AS=1.5P AD=1.5P PS=5U
+ PD=5U
M$39 \$181 \$180 EN|VDD EN|VDD pfet_03v3 L=0.3U W=1.5U AS=1.5P AD=1.5P PS=5U
+ PD=5U
M$40 \$182 \$181 EN|VDD EN|VDD pfet_03v3 L=0.3U W=1.5U AS=1.5P AD=1.5P PS=5U
+ PD=5U
M$41 \$183 \$182 EN|VDD EN|VDD pfet_03v3 L=0.3U W=1.5U AS=1.5P AD=1.5P PS=5U
+ PD=5U
M$42 \$184 \$183 EN|VDD EN|VDD pfet_03v3 L=0.3U W=1.5U AS=1.5P AD=1.5P PS=5U
+ PD=5U
M$43 \$185 \$184 EN|VDD EN|VDD pfet_03v3 L=0.3U W=1.5U AS=1.5P AD=1.5P PS=5U
+ PD=5U
M$44 \$186 \$185 EN|VDD EN|VDD pfet_03v3 L=0.3U W=1.5U AS=1.5P AD=1.5P PS=5U
+ PD=5U
M$45 \$187 \$186 EN|VDD EN|VDD pfet_03v3 L=0.3U W=1.5U AS=1.5P AD=1.5P PS=5U
+ PD=5U
M$46 \$188 \$187 EN|VDD EN|VDD pfet_03v3 L=0.3U W=1.5U AS=1.5P AD=1.5P PS=5U
+ PD=5U
M$47 \$189 \$188 EN|VDD EN|VDD pfet_03v3 L=0.3U W=1.5U AS=1.5P AD=1.5P PS=5U
+ PD=5U
M$48 \$190 \$189 EN|VDD EN|VDD pfet_03v3 L=0.3U W=1.5U AS=1.5P AD=1.5P PS=5U
+ PD=5U
M$49 \$191 \$190 EN|VDD EN|VDD pfet_03v3 L=0.3U W=1.5U AS=1.5P AD=1.5P PS=5U
+ PD=5U
M$50 \$192 \$191 EN|VDD EN|VDD pfet_03v3 L=0.3U W=1.5U AS=1.5P AD=1.5P PS=5U
+ PD=5U
M$51 \$193 \$192 EN|VDD EN|VDD pfet_03v3 L=0.3U W=1.5U AS=1.5P AD=1.5P PS=5U
+ PD=5U
M$52 \$194 \$193 EN|VDD EN|VDD pfet_03v3 L=0.3U W=1.5U AS=1.5P AD=1.5P PS=5U
+ PD=5U
M$53 \$195 \$194 EN|VDD EN|VDD pfet_03v3 L=0.3U W=1.5U AS=1.5P AD=1.5P PS=5U
+ PD=5U
M$54 \$196 \$195 EN|VDD EN|VDD pfet_03v3 L=0.3U W=1.5U AS=1.5P AD=1.5P PS=5U
+ PD=5U
M$55 \$197 \$196 EN|VDD EN|VDD pfet_03v3 L=0.3U W=1.5U AS=1.5P AD=1.5P PS=5U
+ PD=5U
M$56 \$198 \$197 EN|VDD EN|VDD pfet_03v3 L=0.3U W=1.5U AS=1.5P AD=1.5P PS=5U
+ PD=5U
M$57 \$199 \$198 EN|VDD EN|VDD pfet_03v3 L=0.3U W=1.5U AS=1.5P AD=1.5P PS=5U
+ PD=5U
M$58 DN|UP \$199 EN|VDD EN|VDD pfet_03v3 L=0.3U W=1.5U AS=1.5P AD=1.5P PS=5U
+ PD=5U
M$59 IBP|VBP B0B|ENB \$95 EN|VDD pfet_03v3 L=0.3U W=1U AS=0.5P AD=0.5P PS=3U
+ PD=3U
M$60 \$95 B0|EN EN|VDD EN|VDD pfet_03v3 L=0.3U W=1U AS=0.5P AD=0.5P PS=3U PD=3U
M$61 \$96 \$95 EN|VDD EN|VDD pfet_03v3 L=1U W=12U AS=6P AD=6P PS=25U PD=25U
M$62 TAIL|UPT ICP|VCASCP \$96 EN|VDD pfet_03v3 L=1U W=12U AS=6P AD=6P PS=25U
+ PD=25U
M$63 IBP|VBP ENB|VSS \$160 EN|VDD pfet_03v3 L=0.3U W=1U AS=0.5P AD=0.5P PS=3U
+ PD=3U
M$64 \$160 EN|VDD EN|VDD EN|VDD pfet_03v3 L=0.3U W=1U AS=0.5P AD=0.5P PS=3U
+ PD=3U
M$65 TAIL|UPT ICP|VCASCP \$161 EN|VDD pfet_03v3 L=1U W=12U AS=6P AD=6P PS=25U
+ PD=25U
M$66 \$161 \$160 EN|VDD EN|VDD pfet_03v3 L=1U W=12U AS=6P AD=6P PS=25U PD=25U
M$67 \$97 B1|EN EN|VDD EN|VDD pfet_03v3 L=0.3U W=1U AS=0.5P AD=0.5P PS=3U PD=3U
M$68 IBP|VBP B1B|ENB \$97 EN|VDD pfet_03v3 L=0.3U W=1U AS=0.5P AD=0.5P PS=3U
+ PD=3U
M$69 \$98 \$97 EN|VDD EN|VDD pfet_03v3 L=1U W=12U AS=6P AD=6P PS=25U PD=25U
M$70 TAIL|UPT ICP|VCASCP \$98 EN|VDD pfet_03v3 L=1U W=12U AS=6P AD=6P PS=25U
+ PD=25U
M$71 TAIL|UPT \$307 VOUT|VREF EN|VDD pfet_03v3 L=0.3U W=6U AS=3P AD=3P PS=13U
+ PD=13U
M$72 TAIL|UPT UP VDUMP EN|VDD pfet_03v3 L=0.3U W=6U AS=3P AD=3P PS=13U PD=13U
M$73 VOUT|VREF UP VOUT|VREF EN|VDD pfet_03v3 L=0.3U W=3U AS=1.5P AD=1.5P PS=7U
+ PD=7U
M$74 EN|VDD B0|EN B0B|ENB EN|VDD pfet_03v3 L=0.3U W=1.5U AS=0.75P AD=0.75P
+ PS=4U PD=4U
M$75 EN|VDD B1|EN B1B|ENB EN|VDD pfet_03v3 L=0.3U W=1.5U AS=0.75P AD=0.75P
+ PS=4U PD=4U
M$76 \$278 B1|EN EN|VDD EN|VDD pfet_03v3 L=0.3U W=1U AS=0.5P AD=0.5P PS=3U PD=3U
M$77 IBP|VBP B1B|ENB \$278 EN|VDD pfet_03v3 L=0.3U W=1U AS=0.5P AD=0.5P PS=3U
+ PD=3U
M$78 TAIL|UPT ICP|VCASCP \$279 EN|VDD pfet_03v3 L=1U W=12U AS=6P AD=6P PS=25U
+ PD=25U
M$79 \$279 \$278 EN|VDD EN|VDD pfet_03v3 L=1U W=12U AS=6P AD=6P PS=25U PD=25U
M$80 EN|VDD UP \$307 EN|VDD pfet_03v3 L=0.3U W=1.5U AS=0.75P AD=0.75P PS=4U
+ PD=4U
M$81 EN|VDD DN \$306 EN|VDD pfet_03v3 L=0.3U W=1.5U AS=0.75P AD=0.75P PS=4U
+ PD=4U
M$82 \$266 IBP|VBP EN|VDD EN|VDD pfet_03v3 L=1U W=48U AS=24P AD=24P PS=98U
+ PD=98U
M$84 \$267 VOUT|VREF \$266 \$266 pfet_03v3 L=1U W=48U AS=24P AD=24P PS=98U
+ PD=98U
M$85 VDUMP VDUMP \$266 \$266 pfet_03v3 L=1U W=48U AS=24P AD=24P PS=98U PD=98U
M$88 \$3 IBN|VBN ENB|VSS VSS nfet_03v3 L=1U W=16U AS=8P AD=8P PS=33U PD=33U
M$89 \$4 VOUT|VREF \$3 VSS nfet_03v3 L=1U W=16U AS=8P AD=8P PS=33U PD=33U
M$90 VDUMP VDUMP \$3 VSS nfet_03v3 L=1U W=16U AS=8P AD=8P PS=33U PD=33U
M$91 \$21 REF \$20 VSS nfet_03v3 L=0.3U W=1U AS=1P AD=1P PS=4U PD=4U
M$92 ENB|VSS \$19 \$21 VSS nfet_03v3 L=0.3U W=1U AS=1P AD=1P PS=4U PD=4U
M$93 \$24 \$23 UP VSS nfet_03v3 L=0.3U W=1U AS=1P AD=1P PS=4U PD=4U
M$94 ENB|VSS \$74 \$24 VSS nfet_03v3 L=0.3U W=1U AS=1P AD=1P PS=4U PD=4U
M$95 \$25 DN|UP \$74 VSS nfet_03v3 L=0.3U W=1U AS=1P AD=1P PS=4U PD=4U
M$96 ENB|VSS UP \$25 VSS nfet_03v3 L=0.3U W=1U AS=1P AD=1P PS=4U PD=4U
M$97 \$27 UP \$26 VSS nfet_03v3 L=0.3U W=1U AS=1P AD=1P PS=4U PD=4U
M$98 ENB|VSS DN \$27 VSS nfet_03v3 L=0.3U W=1U AS=1P AD=1P PS=4U PD=4U
M$99 \$28 DN ENB|VSS VSS nfet_03v3 L=0.3U W=1U AS=1P AD=1P PS=4U PD=4U
M$100 \$77 DN|UP \$28 VSS nfet_03v3 L=0.3U W=1U AS=1P AD=1P PS=4U PD=4U
M$101 \$29 \$77 ENB|VSS VSS nfet_03v3 L=0.3U W=1U AS=1P AD=1P PS=4U PD=4U
M$102 DN \$78 \$29 VSS nfet_03v3 L=0.3U W=1U AS=1P AD=1P PS=4U PD=4U
M$103 \$32 \$79 ENB|VSS VSS nfet_03v3 L=0.3U W=1U AS=1P AD=1P PS=4U PD=4U
M$104 \$31 FB \$32 VSS nfet_03v3 L=0.3U W=1U AS=1P AD=1P PS=4U PD=4U
M$105 \$15 REF ENB|VSS VSS nfet_03v3 L=0.3U W=0.5U AS=0.5P AD=0.5P PS=3U PD=3U
M$106 \$16 \$15 ENB|VSS VSS nfet_03v3 L=0.3U W=0.5U AS=0.5P AD=0.5P PS=3U PD=3U
M$107 \$17 \$16 ENB|VSS VSS nfet_03v3 L=0.3U W=0.5U AS=0.5P AD=0.5P PS=3U PD=3U
M$108 \$18 \$17 ENB|VSS VSS nfet_03v3 L=0.3U W=0.5U AS=0.5P AD=0.5P PS=3U PD=3U
M$109 \$19 \$18 ENB|VSS VSS nfet_03v3 L=0.3U W=0.5U AS=0.5P AD=0.5P PS=3U PD=3U
M$110 \$22 \$20 ENB|VSS VSS nfet_03v3 L=0.3U W=0.5U AS=0.5P AD=0.5P PS=3U PD=3U
M$111 \$23 \$22 ENB|VSS VSS nfet_03v3 L=0.3U W=0.5U AS=0.5P AD=0.5P PS=3U PD=3U
M$112 ENB|VSS \$30 \$78 VSS nfet_03v3 L=0.3U W=0.5U AS=0.5P AD=0.5P PS=3U PD=3U
M$113 ENB|VSS \$31 \$30 VSS nfet_03v3 L=0.3U W=0.5U AS=0.5P AD=0.5P PS=3U PD=3U
M$114 ENB|VSS \$33 \$79 VSS nfet_03v3 L=0.3U W=0.5U AS=0.5P AD=0.5P PS=3U PD=3U
M$115 ENB|VSS \$34 \$33 VSS nfet_03v3 L=0.3U W=0.5U AS=0.5P AD=0.5P PS=3U PD=3U
M$116 ENB|VSS \$35 \$34 VSS nfet_03v3 L=0.3U W=0.5U AS=0.5P AD=0.5P PS=3U PD=3U
M$117 ENB|VSS \$36 \$35 VSS nfet_03v3 L=0.3U W=0.5U AS=0.5P AD=0.5P PS=3U PD=3U
M$118 ENB|VSS FB \$36 VSS nfet_03v3 L=0.3U W=0.5U AS=0.5P AD=0.5P PS=3U PD=3U
M$119 IBN|VBN IBN|VBN ENB|VSS VSS nfet_03v3 L=1U W=16U AS=8P AD=8P PS=33U PD=33U
M$120 ICN|VCASCN ICN|VCASCN ENB|VSS VSS nfet_03v3 L=1U W=4U AS=2P AD=2P PS=9U
+ PD=9U
M$121 \$175 \$26 ENB|VSS VSS nfet_03v3 L=0.3U W=0.5U AS=0.5P AD=0.5P PS=3U PD=3U
M$122 \$176 \$175 ENB|VSS VSS nfet_03v3 L=0.3U W=0.5U AS=0.5P AD=0.5P PS=3U
+ PD=3U
M$123 \$177 \$176 ENB|VSS VSS nfet_03v3 L=0.3U W=0.5U AS=0.5P AD=0.5P PS=3U
+ PD=3U
M$124 \$178 \$177 ENB|VSS VSS nfet_03v3 L=0.3U W=0.5U AS=0.5P AD=0.5P PS=3U
+ PD=3U
M$125 \$179 \$178 ENB|VSS VSS nfet_03v3 L=0.3U W=0.5U AS=0.5P AD=0.5P PS=3U
+ PD=3U
M$126 \$180 \$179 ENB|VSS VSS nfet_03v3 L=0.3U W=0.5U AS=0.5P AD=0.5P PS=3U
+ PD=3U
M$127 \$181 \$180 ENB|VSS VSS nfet_03v3 L=0.3U W=0.5U AS=0.5P AD=0.5P PS=3U
+ PD=3U
M$128 \$182 \$181 ENB|VSS VSS nfet_03v3 L=0.3U W=0.5U AS=0.5P AD=0.5P PS=3U
+ PD=3U
M$129 \$183 \$182 ENB|VSS VSS nfet_03v3 L=0.3U W=0.5U AS=0.5P AD=0.5P PS=3U
+ PD=3U
M$130 \$184 \$183 ENB|VSS VSS nfet_03v3 L=0.3U W=0.5U AS=0.5P AD=0.5P PS=3U
+ PD=3U
M$131 \$185 \$184 ENB|VSS VSS nfet_03v3 L=0.3U W=0.5U AS=0.5P AD=0.5P PS=3U
+ PD=3U
M$132 \$186 \$185 ENB|VSS VSS nfet_03v3 L=0.3U W=0.5U AS=0.5P AD=0.5P PS=3U
+ PD=3U
M$133 \$187 \$186 ENB|VSS VSS nfet_03v3 L=0.3U W=0.5U AS=0.5P AD=0.5P PS=3U
+ PD=3U
M$134 \$188 \$187 ENB|VSS VSS nfet_03v3 L=0.3U W=0.5U AS=0.5P AD=0.5P PS=3U
+ PD=3U
M$135 \$189 \$188 ENB|VSS VSS nfet_03v3 L=0.3U W=0.5U AS=0.5P AD=0.5P PS=3U
+ PD=3U
M$136 \$190 \$189 ENB|VSS VSS nfet_03v3 L=0.3U W=0.5U AS=0.5P AD=0.5P PS=3U
+ PD=3U
M$137 \$191 \$190 ENB|VSS VSS nfet_03v3 L=0.3U W=0.5U AS=0.5P AD=0.5P PS=3U
+ PD=3U
M$138 \$192 \$191 ENB|VSS VSS nfet_03v3 L=0.3U W=0.5U AS=0.5P AD=0.5P PS=3U
+ PD=3U
M$139 \$193 \$192 ENB|VSS VSS nfet_03v3 L=0.3U W=0.5U AS=0.5P AD=0.5P PS=3U
+ PD=3U
M$140 \$194 \$193 ENB|VSS VSS nfet_03v3 L=0.3U W=0.5U AS=0.5P AD=0.5P PS=3U
+ PD=3U
M$141 \$195 \$194 ENB|VSS VSS nfet_03v3 L=0.3U W=0.5U AS=0.5P AD=0.5P PS=3U
+ PD=3U
M$142 \$196 \$195 ENB|VSS VSS nfet_03v3 L=0.3U W=0.5U AS=0.5P AD=0.5P PS=3U
+ PD=3U
M$143 \$197 \$196 ENB|VSS VSS nfet_03v3 L=0.3U W=0.5U AS=0.5P AD=0.5P PS=3U
+ PD=3U
M$144 \$198 \$197 ENB|VSS VSS nfet_03v3 L=0.3U W=0.5U AS=0.5P AD=0.5P PS=3U
+ PD=3U
M$145 \$199 \$198 ENB|VSS VSS nfet_03v3 L=0.3U W=0.5U AS=0.5P AD=0.5P PS=3U
+ PD=3U
M$146 DN|UP \$199 ENB|VSS VSS nfet_03v3 L=0.3U W=0.5U AS=0.5P AD=0.5P PS=3U
+ PD=3U
M$147 IBN|VBN B0|EN \$91 VSS nfet_03v3 L=0.3U W=1U AS=0.5P AD=0.5P PS=3U PD=3U
M$148 \$91 B0B|ENB ENB|VSS VSS nfet_03v3 L=0.3U W=1U AS=0.5P AD=0.5P PS=3U PD=3U
M$149 \$92 \$91 ENB|VSS VSS nfet_03v3 L=1U W=4U AS=2P AD=2P PS=9U PD=9U
M$150 DNT|TAIL ICN|VCASCN \$92 VSS nfet_03v3 L=1U W=4U AS=2P AD=2P PS=9U PD=9U
M$151 IBN|VBN EN|VDD \$158 VSS nfet_03v3 L=0.3U W=1U AS=0.5P AD=0.5P PS=3U PD=3U
M$152 \$158 ENB|VSS ENB|VSS VSS nfet_03v3 L=0.3U W=1U AS=0.5P AD=0.5P PS=3U
+ PD=3U
M$153 \$159 \$158 ENB|VSS VSS nfet_03v3 L=1U W=4U AS=2P AD=2P PS=9U PD=9U
M$154 \$93 B1B|ENB ENB|VSS VSS nfet_03v3 L=0.3U W=1U AS=0.5P AD=0.5P PS=3U PD=3U
M$155 IBN|VBN B1|EN \$93 VSS nfet_03v3 L=0.3U W=1U AS=0.5P AD=0.5P PS=3U PD=3U
M$156 \$94 \$93 ENB|VSS VSS nfet_03v3 L=1U W=4U AS=2P AD=2P PS=9U PD=9U
M$157 DNT|TAIL ICN|VCASCN \$94 VSS nfet_03v3 L=1U W=4U AS=2P AD=2P PS=9U PD=9U
M$158 VOUT|VREF DN DNT|TAIL VSS nfet_03v3 L=0.3U W=6U AS=3P AD=3P PS=13U PD=13U
M$159 VDUMP \$306 DNT|TAIL VSS nfet_03v3 L=0.3U W=6U AS=3P AD=3P PS=13U PD=13U
M$160 IBN|VBN B1|EN \$264 VSS nfet_03v3 L=0.3U W=1U AS=0.5P AD=0.5P PS=3U PD=3U
M$161 \$264 B1B|ENB ENB|VSS VSS nfet_03v3 L=0.3U W=1U AS=0.5P AD=0.5P PS=3U
+ PD=3U
M$162 DNT|TAIL ICN|VCASCN \$265 VSS nfet_03v3 L=1U W=4U AS=2P AD=2P PS=9U PD=9U
M$163 \$265 \$264 ENB|VSS VSS nfet_03v3 L=1U W=4U AS=2P AD=2P PS=9U PD=9U
M$164 DNT|TAIL ICN|VCASCN \$159 VSS nfet_03v3 L=1U W=4U AS=2P AD=2P PS=9U PD=9U
M$165 VOUT|VREF \$306 VOUT|VREF VSS nfet_03v3 L=0.3U W=3U AS=1.5P AD=1.5P PS=7U
+ PD=7U
M$166 B0B|ENB B0|EN ENB|VSS VSS nfet_03v3 L=0.3U W=0.5U AS=0.25P AD=0.25P PS=2U
+ PD=2U
M$167 B1B|ENB B1|EN ENB|VSS VSS nfet_03v3 L=0.3U W=0.5U AS=0.25P AD=0.25P PS=2U
+ PD=2U
M$168 \$307 UP ENB|VSS VSS nfet_03v3 L=0.3U W=0.5U AS=0.25P AD=0.25P PS=2U PD=2U
M$169 \$306 DN ENB|VSS VSS nfet_03v3 L=0.3U W=0.5U AS=0.25P AD=0.25P PS=2U PD=2U
M$170 \$267 \$267 ENB|VSS VSS nfet_03v3 L=1U W=16U AS=8P AD=8P PS=33U PD=33U
M$171 VDUMP \$267 ENB|VSS VSS nfet_03v3 L=1U W=16U AS=8P AD=8P PS=33U PD=33U
.ENDS pfd_cp
