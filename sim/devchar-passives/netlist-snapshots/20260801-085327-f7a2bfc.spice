* Frozen netlist snapshot for record 20260801-085327-f7a2bfc
* source     : sim/devchar-passives/testbench-res/tb_res.spice
* sha256     : 7d5bba5db74a9260495424548f22e32874f28fafe07deb4f6a893415c68ee01e
* This is a verbatim copy taken at record time. Do not edit.
* gf180-pll :: devchar-passives :: loop-filter resistor comparison
*
* sim/harness NETLIST FRAGMENT. Identical circuit to the pre-migration deck
* `tb_res.sp`; the only edits are the ones the harness's fragment contract
* requires (see sim/harness/README.md): the `.option` card moved to the
* manifest's `options`, and the `.control` block's `dc` sweep + `wrdata` moved
* to the manifest's `analyses` + `raw_measures`. Device instances, geometry
* and node names are byte-for-byte the pre-migration deck.
*
* Poly resistor candidates for the loop filter series resistor, each drawn at
* two lengths so that sheet resistance can be separated from the fixed head
* resistance of the contacts:
*
*   ppolyf_u      unsalicided p+ poly, the analog baseline (~350 ohm/sq)
*   ppolyf_u_1k   high-sheet p+ poly (~1 kohm/sq)
*   ppolyf_u_2k   high-sheet p+ poly (~2 kohm/sq)
*   ppolyf_u_3k   high-sheet p+ poly (~3 kohm/sq)
*   npolyf_u      unsalicided n+ poly (~310 ohm/sq), for polarity comparison
*   ppolyf_s      salicided p+ poly (~7 ohm/sq), included to show why a
*                 salicided resistor is not a loop-filter candidate
*
* Measurement topology: every device sits between a shared swept node and
* ground, with its own 0 V ammeter; the substrate terminal is grounded. A DC
* sweep of 0 -> 1.0 V gives R(V) = V/I, so the voltage coefficient is measured
* rather than assumed. Two lengths (10 um and 50 um at W = 1 um) let run.sh
* extract the effective sheet resistance from the slope
*   rsh_eff = (R(50um) - R(10um)) / ((50 - 10) squares)
* which cancels the contact head resistance, and back out that head resistance
* as the intercept. ppolyf_u is additionally drawn at W = 2 um to expose the
* effective-width narrowing that makes rsh_eff differ from the model rsh.
*
* The harness supplies (see sim/harness/README.md):
*   .lib <corner bundle sections>   res_typical | res_ff | res_ss (+ the other
*                                   families at *_typical -- unused by this deck)
*   .temp <temp_c>
*   .param vdd_val / vdd_nom / temp_c   (unused: this deck's voltage axis is
*                                        the 0..1.0 V device sweep, not supply)
.param wr=1u
.param wr2=2u
.param lshort=10u
.param llong=50u

vr r 0 dc 0

*--------------------------------------------------------------- ppolyf_u, W=1u
vam_pu_s r n_pu_s 0
xpu_s n_pu_s 0 0 ppolyf_u r_width=wr r_length=lshort
vam_pu_l r n_pu_l 0
xpu_l n_pu_l 0 0 ppolyf_u r_width=wr r_length=llong

*--------------------------------------------------------------- ppolyf_u, W=2u
vam_pu2_s r n_pu2_s 0
xpu2_s n_pu2_s 0 0 ppolyf_u r_width=wr2 r_length=lshort
vam_pu2_l r n_pu2_l 0
xpu2_l n_pu2_l 0 0 ppolyf_u r_width=wr2 r_length=llong

*------------------------------------------------------------------ ppolyf_u_1k
vam_p1k_s r n_p1k_s 0
xp1k_s n_p1k_s 0 0 ppolyf_u_1k r_width=wr r_length=lshort
vam_p1k_l r n_p1k_l 0
xp1k_l n_p1k_l 0 0 ppolyf_u_1k r_width=wr r_length=llong

*------------------------------------------------------------------ ppolyf_u_2k
vam_p2k_s r n_p2k_s 0
xp2k_s n_p2k_s 0 0 ppolyf_u_2k r_width=wr r_length=lshort
vam_p2k_l r n_p2k_l 0
xp2k_l n_p2k_l 0 0 ppolyf_u_2k r_width=wr r_length=llong

*------------------------------------------------------------------ ppolyf_u_3k
vam_p3k_s r n_p3k_s 0
xp3k_s n_p3k_s 0 0 ppolyf_u_3k r_width=wr r_length=lshort
vam_p3k_l r n_p3k_l 0
xp3k_l n_p3k_l 0 0 ppolyf_u_3k r_width=wr r_length=llong

*--------------------------------------------------------------------- npolyf_u
vam_nu_s r n_nu_s 0
xnu_s n_nu_s 0 0 npolyf_u r_width=wr r_length=lshort
vam_nu_l r n_nu_l 0
xnu_l n_nu_l 0 0 npolyf_u r_width=wr r_length=llong

*--------------------------------------------------------------------- ppolyf_s
vam_ps_s r n_ps_s 0
xps_s n_ps_s 0 0 ppolyf_s r_width=wr r_length=lshort
vam_ps_l r n_ps_l 0
xps_l n_ps_l 0 0 ppolyf_s r_width=wr r_length=llong
