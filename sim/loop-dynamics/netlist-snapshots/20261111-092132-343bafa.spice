* Frozen netlist snapshot for record 20261111-092132-343bafa
* sources    : 20260731-202550-82af5a9.spice + tb_loop_dynamics.spice (composed at record time, in this order)
* sha256     : 7500e57d8536453bcb92790b46de11ce0273501b56d4ceb7e9018bce3b86fcb0 (of this composed text)
* This is a verbatim composition taken at record time. Do not edit.

* ---- sim/loop-dynamics/netlist-snapshots/20260731-202550-82af5a9.spice (sha256 e4c2184f4be314f9dc5f9fef16d16a57ad4905a71b7f5fd287b8e1c1ee515b01)
* gf180-pll :: loop_filter -- generated by design/netlist.sh from loop_filter.sch
* xschem XSCHEM V3.4.7; do not edit by hand.
** sch_path: design/loop_filter.sch
.subckt loop_filter VCTRL VSS
*.iopin VCTRL
*.iopin VSS
XRF1 NR1 VCTRL VSS ppolyf_u r_width=2u r_length=107u m=1
XRF2 NR2 NR1 VSS ppolyf_u r_width=2u r_length=107u m=1
XRF3 NR3 NR2 VSS ppolyf_u r_width=2u r_length=107u m=1
XRF4 NZ NR3 VSS ppolyf_u r_width=2u r_length=107u m=1
XCF1 NZ VSS cap_nmos_03v3_b c_width=87u c_length=87u m=1
XCF2 NZ VSS cap_nmos_03v3_b c_width=87u c_length=87u m=1
XCF3 NZ VSS cap_nmos_03v3_b c_width=87u c_length=87u m=1
XCF4 NZ VSS cap_nmos_03v3_b c_width=87u c_length=87u m=1
XCF5 VCTRL VSS cap_mim_2f0_m2m3_noshield c_width=31.4u c_length=31.4u m=1
.ends

* ---- sim/loop-dynamics/testbench/tb_loop_dynamics.spice (sha256 b899019a3028d40533e3a15875e16efa76e092b5d32e5d58974da8337e18a805)
* gf180-pll :: loop-dynamics :: passive loop filter, harness form
*
* One fragment carrying BOTH benches of the pre-migration campaign, because the
* harness runs one deck per grid point and a sweep axis (`bench`, see tb.json)
* selects which bench a point is for:
*
*   bench z    small-signal impedance Z(jw) of the real `loop_filter` devices,
*              six Vctrl bias points per invocation (formerly
*              tb_loop_filter_ac.sp).  The open-loop gain of the type-II
*              charge-pump loop is T(s) = A*Z(s)/s with A = Icp*Kvco/N, so one
*              measured Z(jw) per (passive corner, temperature, Vctrl) covers
*              the whole Kvco x N x Icp-trim x f_ref cross-product exactly --
*              see analyze.py.
*   bench xc   independent cross-check: the WHOLE linearized loop (behavioural
*              PFD/CP + real filter + behavioural VCO + divider) at one real
*              (Icp, Kvco, N) design point, T(jw) simulated directly (formerly
*              tb_loop_ac.sp).
*
* Both benches are always present in the deck; they share no node, so the
* linear AC solution of either is untouched by the other.  A point simply reads
* the output file of its own bench and ignores the other's.  The sweep range
* (fstart) is a per-point parameter: 100 Hz for bench z, 10 Hz for bench xc, as
* in the pre-migration decks.
*
* Z bench: six independent filter copies, each fed by a 1 A AC current source,
* each DC-biased through a 1 TH inductor from its own DC source.  At 10-100 Hz
* the inductor's reactance is >= 6e13 ohm, orders above |Z|, so the bias path is
* invisible to the AC result while still giving each node a DC operating point.
* With 1 A of drive, v(vcN) IS Z(jw) in ohms.
*
* xc bench:
*   v(phe)  phase error at the PFD input, 1 rad AC
*   gcp     tri-state PFD + charge pump, small-signal gain Icp/2pi  [A/rad]
*   xfl     THE REAL FILTER
*   gvco    ring VCO as an ideal integrator, 2pi*Kvco amps into 1 F
*   ediv    feedback divider, 1/N, phase-domain
*   T(jw) = v(fb)/v(phe) = v(fb)
*
* The DUT (`loop_filter` subcircuit) is composed ahead of this fragment by the
* harness (`dut` in tb.json); the .lib sections and .temp come from the corner.

.param twopi=6.283185307179586

* ---- bench z ------------------------------------------------------------
* Control-node bias points.  0.9-2.7 V is the usable Vctrl window of DR-003
* Decision 5; 0.3 V is BELOW it and is characterized only for the MOS cap's C-V
* behaviour during cold-start acquisition.
.param vb1=0.3
.param vb2=0.9
.param vb3=1.35
.param vb4=1.8
.param vb5=2.25
.param vb6=2.7

xf1 vc1 0 loop_filter
i1  0 vc1 dc 0 ac 1
lb1 vc1 nb1 1e12
vb1 nb1 0 dc {vb1}

xf2 vc2 0 loop_filter
i2  0 vc2 dc 0 ac 1
lb2 vc2 nb2 1e12
vb2 nb2 0 dc {vb2}

xf3 vc3 0 loop_filter
i3  0 vc3 dc 0 ac 1
lb3 vc3 nb3 1e12
vb3 nb3 0 dc {vb3}

xf4 vc4 0 loop_filter
i4  0 vc4 dc 0 ac 1
lb4 vc4 nb4 1e12
vb4 nb4 0 dc {vb4}

xf5 vc5 0 loop_filter
i5  0 vc5 dc 0 ac 1
lb5 vc5 nb5 1e12
vb5 nb5 0 dc {vb5}

xf6 vc6 0 loop_filter
i6  0 vc6 dc 0 ac 1
lb6 vc6 nb6 1e12
vb6 nb6 0 dc {vb6}

* ---- bench xc -----------------------------------------------------------
vphe phe 0 dc 0 ac 1

* charge pump: Icp/2pi amps per radian, injected into the filter node
gcp 0 vcl phe 0 {icp/twopi}

* the real loop filter
xfl vcl 0 loop_filter

lbias vcl nbias 1e12
vbias nbias 0 dc {vctrl}

* VCO as a phase integrator
gvco 0 pout vcl 0 {twopi*kvco}
cint pout 0 1
rint pout 0 1e15

* feedback divider
ediv fb 0 pout 0 {1/ndiv}
