* gf180-pll :: vco-tuning-range :: open-loop f(Vctrl) / Kvco characterization
*
* RUN-SPECIFIC COPY -- tightened transient timestep (#1059). This directory is
* a one-curve re-run bench, not the campaign's main testbench: it is
* byte-identical to ../testbench/tb_vco_tuning.spice except that `w_max` is
* halved (160 timesteps per cycle of the fastest copy instead of 80), and its
* manifest omits the multi-band derived tables. It exists to test whether a
* smaller maximum timestep changes the f6 dip acceptance check 5 found on the
* `all-fast/27C/3.30V` band-1 curve of batch record
* `20261118-021803-deb4ec0`. Settling window, measurement crossings, per-point
* measures and topology are unchanged; solver tolerances are unchanged.
*
* sim/harness netlist FRAGMENT (see sim/harness/README.md). The DUT is the
* committed export design/netlist/vco.spice, composed ahead of this fragment by
* the manifest's `dut` key -- this file instantiates the block, it never
* contains a copy of it.
*
* Migrated from the sim/lib/simenv.sh-based tb_vco_tuning.sp + run.sh pair. The
* measured circuit is unchanged: same seven-copy topology, same band-code
* drive, same .ic start-up, same trig/targ measurement criterion.
*
* Measurement topology
*   Seven independent copies of the whole VCO (bias generator + ring + output
*   buffer + on-chip decoupling) are instantiated in one deck, one per control
*   voltage, all at the same PVT point and the same band code. Each copy has its
*   own supply ammeter, so f(Vctrl) and I(Vctrl) at seven control points come out
*   of a single transient. The copies share only the ideal supply node and
*   ground; they are otherwise disjoint, so there is no interaction between them.
*
*   Frequency is measured at the *buffered output* CLK, not at an internal ring
*   node: CLK is what the divider (#11) and the closed-loop bench (#12) see, and
*   measuring there also proves the output buffer resolves the ring's slow edges
*   into a rail-to-rail clock at the bottom of the band.
*
*   Period is taken over four whole cycles between the first and fifth rising
*   half-supply crossing after `w_settle`, so the bias generator's own start-up
*   transient is excluded from the number.
*
* Devices are the PDK 3.3 V thick-oxide wrappers only (nfet_03v3 / pfet_03v3,
* ppolyf_u_3k, cap_nmos_03v3), per DR-002 Decision 3.
*
* From the harness: vdd_val, vdd_nom, temp_c.
* From the manifest's `band` sweep axis: band, b0, b1, b2.

* --- control voltages: 0.9 .. 2.7 V in 0.3 V steps (the usable Vctrl window)
.param vc1=0.9 vc2=1.2 vc3=1.5 vc4=1.8 vc5=2.1 vc6=2.4 vc7=2.7

* ---------------------------------------------------------------------------
* Transient window, sized in-deck.
*
* The window has to track f_osc, which moves by ~2 decades across the band
* codes and by ~4x across PVT -- a single fixed .tran would either miss the
* five rising edges the period measurement needs at the slow end or waste two
* orders of magnitude of timesteps at the fast end. The pre-migration runner
* computed the window in bash per (band, bundle, temp, vdd); the harness owns
* the .tran card, so the estimate is expressed here as .param arithmetic over
* the quantities the deck can see (band, temp_c, vdd_val) and handed to the
* control block through .csparam.
*
* w_flo / w_fhi are a CALIBRATED ENVELOPE, not a result: least-squares fits (in
* log f) of the *minimum-over-process* f at Vctrl = 0.9 V and the
* *maximum-over-process* f at Vctrl = 2.7 V, against all 3528 measured points
* of record 20260731-175947-0a12e6c. Fit residuals over that grid are within
* -3.3%/+2.9% (low envelope) and -7.9%/+3.9% (high envelope); w_margin = 1.10
* covers them ~2.5x over. The process axis is deliberately absorbed into the
* envelope rather than modelled, because a deck cannot see which .lib sections
* the harness selected.
*
* Nothing downstream trusts this estimate: it only sets tstart/tstop/tmax. If
* it were wrong enough to cost a rising edge, the corresponding .measure would
* not land and the harness reports that point as failed -- it can never turn
* into a silently wrong frequency.
.param w_t='(temp_c - 27) / 100'
.param w_v='vdd_val - 3.3'
.param w_llo='15.035565 + 0.485851*band + 0.005016*band*band + 0.058263*w_t - 0.003166*w_t*w_t - 0.291204*w_v - 0.031302*w_v*band + 0.009398*w_t*band'
.param w_lhi='16.308724 + 0.490535*band + 0.006324*band*band + 0.082074*w_t - 0.011226*w_t*w_t - 0.302075*w_v - 0.019553*w_v*band + 0.011608*w_t*band'
.param w_margin=1.10
.param w_flo='exp(w_llo) / w_margin'
.param w_fhi='exp(w_lhi) * w_margin'
* >= 4 periods of the slowest copy before the first measured edge, then 7 more
* periods of measurement window; <= 1/(80 f_max), i.e. >= 80 timesteps per
* cycle of the fastest copy in the deck.
*
* #1059 copy: w_max is HALVED against the main testbench -- 1/(160 f_max),
* i.e. >= 160 timesteps per cycle -- so the transient resolution at the
* dipped point can no longer be limited by the 80-step envelope. The settling
* and measurement windows (w_settle / w_stop) and every .measure card are
* untouched, so the numbers stay directly comparable with record
* 20261118-021803-deb4ec0's row for this curve.
.param w_settle='4 / w_flo'
.param w_stop='w_settle + 7 / w_flo'
.param w_max='1 / (160 * w_fhi)'
.csparam cs_stop={w_stop}
.csparam cs_max={w_max}

vdd  vdd 0 dc 'vdd_val'
vb0  nb0 0 dc 'b0*vdd_val'
vb1  nb1 0 dc 'b1*vdd_val'
vb2  nb2 0 dc 'b2*vdd_val'

vv1 vc1 0 dc 'vc1'
vv2 vc2 0 dc 'vc2'
vv3 vc3 0 dc 'vc3'
vv4 vc4 0 dc 'vc4'
vv5 vc5 0 dc 'vc5'
vv6 vc6 0 dc 'vc6'
vv7 vc7 0 dc 'vc7'

vs1 vdd nv1 dc 0
vs2 vdd nv2 dc 0
vs3 vdd nv3 dc 0
vs4 vdd nv4 dc 0
vs5 vdd nv5 dc 0
vs6 vdd nv6 dc 0
vs7 vdd nv7 dc 0

x1 vc1 nb0 nb1 nb2 clk1 nv1 0 vco
x2 vc2 nb0 nb1 nb2 clk2 nv2 0 vco
x3 vc3 nb0 nb1 nb2 clk3 nv3 0 vco
x4 vc4 nb0 nb1 nb2 clk4 nv4 0 vco
x5 vc5 nb0 nb1 nb2 clk5 nv5 0 vco
x6 vc6 nb0 nb1 nb2 clk6 nv6 0 vco
x7 vc7 nb0 nb1 nb2 clk7 nv7 0 vco

* Break the ring's DC symmetry so the operating point is not the metastable
* all-nodes-at-mid solution; the constraint is released when the transient
* starts. `uic` is deliberately NOT used: the bias generator must be solved to
* its operating point before t=0 or the first microsecond of every run is a
* bias start-up transient rather than the oscillation being measured.
.ic v(x1.Y1)=0 v(x1.Y2)='vdd_val' v(x1.Y3)=0 v(x1.Y4)='vdd_val' v(x1.Y5)=0
.ic v(x2.Y1)=0 v(x2.Y2)='vdd_val' v(x2.Y3)=0 v(x2.Y4)='vdd_val' v(x2.Y5)=0
.ic v(x3.Y1)=0 v(x3.Y2)='vdd_val' v(x3.Y3)=0 v(x3.Y4)='vdd_val' v(x3.Y5)=0
.ic v(x4.Y1)=0 v(x4.Y2)='vdd_val' v(x4.Y3)=0 v(x4.Y4)='vdd_val' v(x4.Y5)=0
.ic v(x5.Y1)=0 v(x5.Y2)='vdd_val' v(x5.Y3)=0 v(x5.Y4)='vdd_val' v(x5.Y5)=0
.ic v(x6.Y1)=0 v(x6.Y2)='vdd_val' v(x6.Y3)=0 v(x6.Y4)='vdd_val' v(x6.Y5)=0
.ic v(x7.Y1)=0 v(x7.Y2)='vdd_val' v(x7.Y3)=0 v(x7.Y4)='vdd_val' v(x7.Y5)=0
