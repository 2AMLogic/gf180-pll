* Extracted by KLayout with GF180MCU LVS runset on : 08/09/2026 19:05

.SUBCKT cp_leg_p EN ENB TAIL VBP VCASCP VDD
M$1 VBP ENB \$4 VDD pfet_03v3 L=0.3U W=1U AS=0.5P AD=0.5P PS=3U PD=3U
M$2 \$5 \$4 VDD VDD pfet_03v3 L=1U W=12U AS=6P AD=6P PS=25U PD=25U
M$3 TAIL VCASCP \$5 VDD pfet_03v3 L=1U W=12U AS=6P AD=6P PS=25U PD=25U
M$4 \$4 EN VDD VDD pfet_03v3 L=0.3U W=1U AS=0.5P AD=0.5P PS=3U PD=3U
.ENDS cp_leg_p
