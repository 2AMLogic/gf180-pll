* gf180-pll :: reference-spur :: closed-loop reference-spur measurement (#145)
*
* WHAT THIS DECK MEASURES, AND WHY IT IS A TRANSIENT.
* The reference spur is the pair of sidebands at +/- f_ref around the carrier
* at f_out, in lock.  It is produced by a NONLINEAR, periodic-steady-state
* mechanism: once per reference cycle the PFD fires both branches for the
* reset-delay overlap, the charge pump's per-event charge asymmetry lands on
* C2, and the resulting Vctrl ripple phase-modulates the ring.  A linearized
* small-signal analysis cannot produce it -- sim/loop-dynamics says so in its
* own Limitations field, and that campaign's AC sweep is of the loop's
* CONTROL response, not of a once-per-reference-cycle charge event.  So this
* deck runs the assembled loop to steady-state lock and the reduction reads
* the sideband out of the output spectrum directly (see derive.py).
*
* Until this deck existed the spur was DERIVED: spec/pll.md's Reference spur
* section chains sim/cp-compliance's charge asymmetry and sim/mc-cp-mismatch's
* residual through a narrowband-FM approximation to -61 dBc, with the
* "Verification owed" table naming the missing measurement.  A derived number
* is not evidence; this deck is the measurement it was standing in for.
*
* DUT: `pll_top` -- the whole PLL, from design/pll_top.sch, netlisted by
* design/netlist.sh into design/netlist/pll_top.spice, which the harness
* composes ahead of this fragment via tb.json's `dut` key.  Nothing here is a
* hand-transcribed copy of the design (#52).  The 32-port instance line and
* every configuration-bit code below are GENERATED by sim/lib/pll_top_dut.sh
* (`cloop_instance`, `cloop_divider_params`, `cloop_band_params`,
* `cloop_trim_params`) and re-checked against it by check_config.sh in this
* directory -- so the bits in tb.json are verified against the single owner of
* that encoding rather than trusted because they look plausible.
*
* Expects from the harness-generated header:
*   vdd_val   supply for this PVT point        vdd_nom  nominal supply
*   temp_c    temperature for this PVT point
* and from tb.json's `params` / `sweeps`:
*   fref      reference frequency, Hz
*   nratio    the divide ratio the SEL/P bits below encode
*   b*_code   VCO band-select bits            (sim/lib/pll_top_dut.sh)
*   cpb*_code charge-pump Icp trim bits       (   "   )
*   sel*_code, p*_code  divider chain-length / modulus bits   (   "   )
*   vstart    control-node voltage the loop is released from, per corner
*   ta, tb    the two late instants the lock criterion is evaluated at
*   w1a, w1b  the EARLY spectral window (start, end)
*   w2a, w2b  the LATE  spectral window (start, end)
*   ktstep, ktstop, ktstart, ktmax   transient controls (see tb.json)

*--------------------------------------------------------------- stimulus ---
* Charge-pump bias references.  Four ideal sources at 4x the unit-leg current,
* exactly as sim/devchar-cp, sim/pfd-deadzone, sim/cp-compliance and
* sim/pll-top-smoke drive them: the bias generator is a separate,
* not-yet-designed block (design/README.md, "Bias generation is out of scope
* for this block"), so driving these ideally keeps the measured behaviour the
* LOOP's own rather than folding in a reference whose mismatch has no design
* behind it yet.
.param iunit=8u

* Reference clock.  200 ps edges rather than an ideal step, for the same
* reason sim/pfd-deadzone and sim/pll-top-smoke use them: a zero-rise-time
* stimulus flatters every delay in the PFD's set path, and the PFD set path is
* precisely what this campaign's timestep ceiling is sized from.
*
* The reference is IDEAL -- no jitter, no duty-cycle error.  That is the
* condition spec/pll.md's Reference spur row is written against ("Reference:
* ideal"), and it is also a LIMITATION of this record: a spur contribution
* driven by reference jitter is out of scope here by construction.
.param tref='1/fref'
.param tstart='0.5*tref'

vvdd     vdd     0 dc 'vdd_val'
vvddvco  vdd_vco 0 dc 'vdd_val'
vvdddiv  vdd_div 0 dc 'vdd_val'
vgndvco  gnd_vco 0 dc 0
vvss     vss     0 dc 0

vref ref 0 pulse(0 'vdd_val' 'tstart' 200p 200p '0.5*tref' 'tref')

* Static configuration.  Every one of these is a real pin on the block: DR-001
* Decision 2 keeps band select a static input with no calibration FSM, and
* DR-001 Decision 3 does the same for N.  The codes come from tb.json.
vb0   b0   0 dc 'vdd_val*b0_code'
vb1   b1   0 dc 'vdd_val*b1_code'
vb2   b2   0 dc 'vdd_val*b2_code'
vcpb0 cpb0 0 dc 'vdd_val*cpb0_code'
vcpb1 cpb1 0 dc 'vdd_val*cpb1_code'
vp0   p0   0 dc 'vdd_val*p0_code'
vp1   p1   0 dc 'vdd_val*p1_code'
vp2   p2   0 dc 'vdd_val*p2_code'
vp3   p3   0 dc 'vdd_val*p3_code'
vp4   p4   0 dc 'vdd_val*p4_code'
vp5   p5   0 dc 'vdd_val*p5_code'
vs0   sel0 0 dc 'vdd_val*sel0_code'
vs1   sel1 0 dc 'vdd_val*sel1_code'
vs2   sel2 0 dc 'vdd_val*sel2_code'
vs3   sel3 0 dc 'vdd_val*sel3_code'
vs4   sel4 0 dc 'vdd_val*sel4_code'
vs5   sel5 0 dc 'vdd_val*sel5_code'

iibn vdd ibn dc 'iunit'
iicn vdd icn dc 'iunit'
iibp ibp 0   dc 'iunit'
iicp icp 0   dc 'iunit'

* The DUT.  This instance line is `cloop_instance`'s output verbatim, so the
* 32-port order is never transcribed by hand.
xdut ref b0 b1 b2 cpb0 cpb1 p0 p1 p2 p3 p4 p5 sel0 sel1 sel2 sel3 sel4 sel5
+ ibn icn ibp icp clk divout fb lock vctrl vdd vdd_vco gnd_vco vdd_div vss
+ pll_top

*--------------------------------------------------------- initial state ---
* The control node is RELEASED at `vstart`, which for THIS campaign is the
* per-corner estimate of the lock point read out of sim/vco-tuning-range's
* committed f(Vctrl) table (record 20260804-162735-72883fb,
* corners/.../raw_measures.csv, band 6, linear interpolation between its seven
* control points).  That is deliberate and it is NOT the cold-start release
* sim/pll-top-smoke and sim/lock-time use:
*
*   - This campaign measures a STEADY-STATE spectral property.  Lock TIME from
*     a cold start is #12's campaign (sim/lock-time) and nothing here may be
*     read as one -- the release point is chosen to get to steady state for
*     the least wall clock, which is exactly what would make a lock-time
*     number from this deck meaningless.
*   - The loop's slow closed-loop pole sits at 1/(R*C1) = 9.3 us regardless of
*     how much Icp is applied (spec/pll.md's ~43 us STRUCTURAL settling floor,
*     DR-006 Decision 7), so the residual control-voltage error decays by one
*     e-fold per 9.3 us no matter where it starts.  Starting ~0.1 V away
*     rather than ~0.7 V away removes the frequency-acquisition slew (the
*     control node slews at only Icp/C1 = 14 mV/us at this trim code) and
*     leaves the exponential tail, which is what actually has to finish.
*   - The residual is not assumed away: `vdrift` below MEASURES it, and
*     derive.py converts it into the per-reference-cycle charge it represents
*     and compares that against the charge-pump asymmetry the spur is made of.
*     A record whose drift charge is a large fraction of the asymmetry charge
*     is reporting an upper bound, and says so.
.ic v(vctrl)='vstart'

* Break the ring's DC symmetry so the operating point is not the metastable
* all-nodes-at-mid solution.  Same constraint sim/vco-tuning-range applies and
* the same release sim/pll-top-smoke uses.  `uic` is deliberately NOT used:
* the VCO's constant-gm bias generator must be solved to its operating point
* before t=0, or the first microseconds would be a bias start-up transient
* masquerading as loop settling.
.ic v(xdut.xvco.y1)=0 v(xdut.xvco.y2)='vdd_val' v(xdut.xvco.y3)=0
+ v(xdut.xvco.y4)='vdd_val' v(xdut.xvco.y5)=0

*-------------------------------------------------------------- lock criterion
* Same criterion sim/pll-top-smoke uses, and for the same reason: a spectral
* number taken from a loop that is not actually locked is not a spur.
*
*   (a) FREQUENCY.  In a type-II loop a residual frequency error shows up as a
*       REF->FB delay that slips linearly at exactly (df/f) seconds per
*       second, so differencing that delay at two instants gives the residual
*       fractional frequency error directly, to picosecond resolution.
*   (b) PHASE.  That static phase error is itself small against a reference
*       period.
*
* ta and tb are placed by tb.json on a reference HALF-period (tstart +
* (k+0.5)*tref), so "the first REF rise after t" and "the first FB rise after
* t" are the same cycle's pair and the measurement cannot alias by a whole
* reference period.  Both are inside the stored window (see ktstart).
*
* The `.measure` cards themselves live in tb.json's `raw_measures` -- the
* harness owns them (a fragment may not carry `.meas`), which is why this
* block is a comment here and a manifest entry there.

*------------------------------------------------------------------ analysis
* rshunt: the charge pump's disabled trim legs leave their cascode mid-node
* driven only by two off devices -- a floating node for the DC operating
* point.  Same 1 Tohm shunt sim/pfd-deadzone and sim/pll-top-smoke use; at
* 3.3 V it is 3.3 pA against a multi-microamp signal.
* itl4: transient Newton-iteration limit, a solver-EFFORT knob.  Every
* convergence TOLERANCE is left at the value the other closed-loop campaigns
* use, so this deck's converged solution is comparable with theirs.
*
* These are in tb.json's `options`, not here, for the same reason as the
* `.measure` cards: the harness owns the generated deck's directives.
