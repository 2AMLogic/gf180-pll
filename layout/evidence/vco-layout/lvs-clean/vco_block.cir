* Extracted by KLayout with GF180MCU LVS runset on : 11/09/2026 09:21

.SUBCKT vco_block B0 B1 B2 CLK GND_VCO NB1 NB2 NC NOFF NVI S1.Y|Y1 S2.Y|Y2
+ S3.Y|Y3 S4.Y|Y4 S5.Y|Y5|Y5_CLK_IN VBN VBP VBP0 VCTRL VDD_VCO
M$1 VDD_VCO GND_VCO \$14 VDD_VCO pfet_03v3 L=20U W=0.22U AS=0.53P AD=0.53P
+ PS=3.84U PD=3.84U
M$2 VDD_VCO \$13 \$11 VDD_VCO pfet_03v3 L=1U W=10U AS=15P AD=15P PS=23U PD=23U
M$3 VDD_VCO \$13 \$13 VDD_VCO pfet_03v3 L=1U W=10U AS=15P AD=15P PS=23U PD=23U
M$4 VDD_VCO \$13 \$12 VDD_VCO pfet_03v3 L=1U W=2.5U AS=3.75P AD=3.75P PS=8U
+ PD=8U
M$5 VDD_VCO VBP0 VBP0 VDD_VCO pfet_03v3 L=1U W=60U AS=90P AD=90P PS=132U PD=132U
M$9 VDD_VCO VBP0 \$41 VDD_VCO pfet_03v3 L=1U W=26.5U AS=39.75P AD=39.75P PS=59U
+ PD=59U
M$10 VDD_VCO \$57 \$41 VDD_VCO pfet_03v3 L=1U W=17.22U AS=25.83P AD=25.83P
+ PS=40.44U PD=40.44U
M$11 VDD_VCO B0 \$40 VDD_VCO pfet_03v3 L=0.28U W=2U AS=3P AD=3P PS=7U PD=7U
M$14 VBP0 \$40 \$57 VDD_VCO pfet_03v3 L=0.5U W=2U AS=3P AD=3P PS=7U PD=7U
M$15 VDD_VCO B0 \$57 VDD_VCO pfet_03v3 L=0.5U W=2U AS=3P AD=3P PS=7U PD=7U
M$16 VDD_VCO B1 \$39 VDD_VCO pfet_03v3 L=0.28U W=2U AS=3P AD=3P PS=7U PD=7U
M$17 VDD_VCO \$42 \$42 VDD_VCO pfet_03v3 L=1U W=20U AS=30P AD=30P PS=43U PD=43U
M$18 VDD_VCO B2 \$43 VDD_VCO pfet_03v3 L=0.28U W=2U AS=3P AD=3P PS=7U PD=7U
M$19 \$42 \$43 \$58 VDD_VCO pfet_03v3 L=0.5U W=2U AS=3P AD=3P PS=7U PD=7U
M$20 VDD_VCO B2 \$58 VDD_VCO pfet_03v3 L=0.5U W=2U AS=3P AD=3P PS=7U PD=7U
M$21 VDD_VCO \$58 VBN VDD_VCO pfet_03v3 L=1U W=78.88U AS=118.32P AD=118.32P
+ PS=181.76U PD=181.76U
M$25 VDD_VCO \$42 VBN VDD_VCO pfet_03v3 L=1U W=12.3U AS=18.45P AD=18.45P
+ PS=27.6U PD=27.6U
M$30 VDD_VCO VBP VBP VDD_VCO pfet_03v3 L=0.5U W=10U AS=15P AD=15P PS=23U PD=23U
M$31 \$111 S5.Y|Y5|Y5_CLK_IN S1.Y|Y1 VDD_VCO pfet_03v3 L=0.28U W=5U AS=2.5P
+ AD=2.5P PS=11U PD=11U
M$32 \$112 S1.Y|Y1 S2.Y|Y2 VDD_VCO pfet_03v3 L=0.28U W=5U AS=2.5P AD=2.5P
+ PS=11U PD=11U
M$33 \$113 S2.Y|Y2 S3.Y|Y3 VDD_VCO pfet_03v3 L=0.28U W=5U AS=2.5P AD=2.5P
+ PS=11U PD=11U
M$34 \$114 S3.Y|Y3 S4.Y|Y4 VDD_VCO pfet_03v3 L=0.28U W=5U AS=2.5P AD=2.5P
+ PS=11U PD=11U
M$35 \$115 S4.Y|Y4 S5.Y|Y5|Y5_CLK_IN VDD_VCO pfet_03v3 L=0.28U W=5U AS=2.5P
+ AD=2.5P PS=11U PD=11U
M$36 VDD_VCO VBP \$111 VDD_VCO pfet_03v3 L=0.5U W=10U AS=5P AD=5P PS=21U PD=21U
M$37 VDD_VCO VBP \$112 VDD_VCO pfet_03v3 L=0.5U W=10U AS=5P AD=5P PS=21U PD=21U
M$38 VDD_VCO VBP \$113 VDD_VCO pfet_03v3 L=0.5U W=10U AS=5P AD=5P PS=21U PD=21U
M$39 VDD_VCO VBP \$114 VDD_VCO pfet_03v3 L=0.5U W=10U AS=5P AD=5P PS=21U PD=21U
M$40 VDD_VCO VBP \$115 VDD_VCO pfet_03v3 L=0.5U W=10U AS=5P AD=5P PS=21U PD=21U
M$41 VDD_VCO S5.Y|Y5|Y5_CLK_IN NB1 VDD_VCO pfet_03v3 L=0.28U W=1.25U AS=0.625P
+ AD=0.625P PS=3.5U PD=3.5U
M$42 VDD_VCO NB1 NB2 VDD_VCO pfet_03v3 L=0.28U W=3.75U AS=1.875P AD=1.875P
+ PS=8.5U PD=8.5U
M$43 VDD_VCO NB2 CLK VDD_VCO pfet_03v3 L=0.28U W=11.25U AS=5.625P AD=5.625P
+ PS=23.5U PD=23.5U
M$44 CLK NB2 GND_VCO GND_VCO nfet_03v3 L=0.28U W=4.5U AS=2.25P AD=2.25P PS=10U
+ PD=10U
M$45 NB2 NB1 GND_VCO GND_VCO nfet_03v3 L=0.28U W=1.5U AS=0.75P AD=0.75P PS=4U
+ PD=4U
M$46 S5.Y|Y5|Y5_CLK_IN S4.Y|Y4 \$96 GND_VCO nfet_03v3 L=0.28U W=2U AS=1P AD=1P
+ PS=5U PD=5U
M$47 S4.Y|Y4 S3.Y|Y3 \$95 GND_VCO nfet_03v3 L=0.28U W=2U AS=1P AD=1P PS=5U PD=5U
M$48 S3.Y|Y3 S2.Y|Y2 \$94 GND_VCO nfet_03v3 L=0.28U W=2U AS=1P AD=1P PS=5U PD=5U
M$49 S1.Y|Y1 S5.Y|Y5|Y5_CLK_IN \$92 GND_VCO nfet_03v3 L=0.28U W=2U AS=1P AD=1P
+ PS=5U PD=5U
M$50 NB1 S5.Y|Y5|Y5_CLK_IN GND_VCO GND_VCO nfet_03v3 L=0.28U W=0.5U AS=0.25P
+ AD=0.25P PS=2U PD=2U
M$51 S2.Y|Y2 S1.Y|Y1 \$93 GND_VCO nfet_03v3 L=0.28U W=2U AS=1P AD=1P PS=5U PD=5U
M$52 \$96 VBN GND_VCO GND_VCO nfet_03v3 L=0.5U W=4U AS=2P AD=2P PS=9U PD=9U
M$53 \$94 VBN GND_VCO GND_VCO nfet_03v3 L=0.5U W=4U AS=2P AD=2P PS=9U PD=9U
M$54 \$93 VBN GND_VCO GND_VCO nfet_03v3 L=0.5U W=4U AS=2P AD=2P PS=9U PD=9U
M$55 \$95 VBN GND_VCO GND_VCO nfet_03v3 L=0.5U W=4U AS=2P AD=2P PS=9U PD=9U
M$56 \$42 \$38 GND_VCO GND_VCO nfet_03v3 L=1U W=8.61U AS=12.915P AD=12.915P
+ PS=23.22U PD=23.22U
M$57 VBP0 \$12 NOFF GND_VCO nfet_03v3 L=1U W=10U AS=15P AD=15P PS=23U PD=23U
M$58 VBN VBN GND_VCO GND_VCO nfet_03v3 L=0.5U W=4U AS=6P AD=6P PS=11U PD=11U
M$59 \$42 \$41 GND_VCO GND_VCO nfet_03v3 L=1U W=5U AS=7.5P AD=7.5P PS=16U PD=16U
M$60 \$41 \$41 GND_VCO GND_VCO nfet_03v3 L=1U W=10U AS=15P AD=15P PS=23U PD=23U
M$61 \$43 B2 GND_VCO GND_VCO nfet_03v3 L=0.28U W=1U AS=1.5P AD=1.5P PS=5U PD=5U
M$62 \$38 B1 \$41 GND_VCO nfet_03v3 L=0.5U W=2U AS=3P AD=3P PS=7U PD=7U
M$63 \$92 VBN GND_VCO GND_VCO nfet_03v3 L=0.5U W=4U AS=2P AD=2P PS=9U PD=9U
M$64 \$39 B1 GND_VCO GND_VCO nfet_03v3 L=0.28U W=1U AS=1.5P AD=1.5P PS=5U PD=5U
M$65 \$40 B0 GND_VCO GND_VCO nfet_03v3 L=0.28U W=1U AS=1.5P AD=1.5P PS=5U PD=5U
M$66 VBP VBN GND_VCO GND_VCO nfet_03v3 L=0.5U W=4U AS=6P AD=6P PS=11U PD=11U
M$67 \$38 \$39 GND_VCO GND_VCO nfet_03v3 L=0.5U W=2U AS=3P AD=3P PS=7U PD=7U
M$68 \$13 \$14 GND_VCO GND_VCO nfet_03v3 L=1U W=1U AS=1.5P AD=1.5P PS=5U PD=5U
M$70 VBP0 VCTRL NVI GND_VCO nfet_03v3 L=1U W=10U AS=15P AD=15P PS=23U PD=23U
M$71 \$11 \$11 GND_VCO GND_VCO nfet_03v3 L=1U W=1.4U AS=2.1P AD=2.1P PS=5.8U
+ PD=5.8U
M$72 \$12 \$12 \$7 GND_VCO nfet_03v3 L=1U W=2U AS=3P AD=3P PS=7U PD=7U
M$73 \$7 \$7 GND_VCO GND_VCO nfet_03v3 L=1U W=2U AS=3P AD=3P PS=7U PD=7U
M$74 \$14 \$11 GND_VCO GND_VCO nfet_03v3 L=1U W=2U AS=3P AD=3P PS=7U PD=7U
M$76 \$13 \$11 NC GND_VCO nfet_03v3 L=1U W=5.6U AS=8.4P AD=8.4P PS=14.2U
+ PD=14.2U
R$77 GND_VCO NC GND_VCO 1960 ppolyf_u L=5.6U W=1U
R$78 GND_VCO NOFF GND_VCO 11550 ppolyf_u L=33U W=1U
R$79 GND_VCO NVI GND_VCO 11550 ppolyf_u L=33U W=1U
.ENDS vco_block
