* Extracted by KLayout with GF180MCU LVS runset on : 08/09/2026 19:04

.SUBCKT cp_leg_n EN ENB TAIL VBN VCASCN VSS
M$1 TAIL VCASCN \$6 VSS nfet_03v3 L=1U W=4U AS=2P AD=2P PS=9U PD=9U
M$2 VBN EN \$2 VSS nfet_03v3 L=0.3U W=1U AS=0.5P AD=0.5P PS=3U PD=3U
M$3 \$6 \$2 VSS VSS nfet_03v3 L=1U W=4U AS=2P AD=2P PS=9U PD=9U
M$4 \$2 ENB VSS VSS nfet_03v3 L=0.3U W=1U AS=0.5P AD=0.5P PS=3U PD=3U
.ENDS cp_leg_n
