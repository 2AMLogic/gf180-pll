** sch_path: design/dut_export.sch

* expanding   symbol:  pfd_cp.sym # of pins=13
** sym_path: design/pfd_cp.sym
** sch_path: design/pfd_cp.sch
.subckt pfd_cp REF FB B0 B1 IBN ICN IBP ICP VOUT UP DN VDD VSS
*.ipin REF
*.ipin FB
*.ipin B0
*.ipin B1
*.iopin IBN
*.iopin ICN
*.iopin IBP
*.iopin ICP
*.iopin VOUT
*.opin UP
*.opin DN
*.iopin VDD
*.iopin VSS
xpfd REF FB UP DN VDD VSS pfd
xcp UP DN B0 B1 IBN ICN IBP ICP VOUT VDD VSS cp
.ends

* expanding   symbol:  pfd.sym # of pins=6
** sym_path: design/pfd.sym
** sch_path: design/pfd.sch
.subckt pfd REF FB UP DN VDD VSS
*.ipin REF
*.ipin FB
*.opin UP
*.opin DN
*.iopin VDD
*.iopin VSS
xed_ref REF PR VDD VSS edgedet
xed_fb FB PF VDD VSS edgedet
xinv_sr PR SBR VDD VSS pfdcp_inv_3v3
xinv_sf PF SBF VDD VSS pfdcp_inv_3v3
xlat_ref SBR RB UP UPB VDD VSS srlatch
xlat_fb SBF RB DN DNB VDD VSS srlatch
xnand_rst UP DN NRST VDD VSS pfdcp_nand2_3v3
xinv_r0 NRST RST_RAW VDD VSS pfdcp_inv_3v3
xd1 RST_RAW RD1 VDD VSS pfdcp_inv_3v3
xd2 RD1 RD2 VDD VSS pfdcp_inv_3v3
xd3 RD2 RD3 VDD VSS pfdcp_inv_3v3
xd4 RD3 RD4 VDD VSS pfdcp_inv_3v3
xd5 RD4 RD5 VDD VSS pfdcp_inv_3v3
xd6 RD5 RD6 VDD VSS pfdcp_inv_3v3
xd7 RD6 RD7 VDD VSS pfdcp_inv_3v3
xd8 RD7 RD8 VDD VSS pfdcp_inv_3v3
xd9 RD8 RD9 VDD VSS pfdcp_inv_3v3
xd10 RD9 RD10 VDD VSS pfdcp_inv_3v3
xd11 RD10 RD11 VDD VSS pfdcp_inv_3v3
xd12 RD11 RD12 VDD VSS pfdcp_inv_3v3
xd13 RD12 RD13 VDD VSS pfdcp_inv_3v3
xd14 RD13 RD14 VDD VSS pfdcp_inv_3v3
xd15 RD14 RD15 VDD VSS pfdcp_inv_3v3
xd16 RD15 RD16 VDD VSS pfdcp_inv_3v3
xd17 RD16 RD17 VDD VSS pfdcp_inv_3v3
xd18 RD17 RD18 VDD VSS pfdcp_inv_3v3
xd19 RD18 RD19 VDD VSS pfdcp_inv_3v3
xd20 RD19 RD20 VDD VSS pfdcp_inv_3v3
xd21 RD20 RD21 VDD VSS pfdcp_inv_3v3
xd22 RD21 RD22 VDD VSS pfdcp_inv_3v3
xd23 RD22 RD23 VDD VSS pfdcp_inv_3v3
xd24 RD23 RST_DLY VDD VSS pfdcp_inv_3v3
xinv_rb RST_DLY RB VDD VSS pfdcp_inv_3v3
.ends

* expanding   symbol:  cp.sym # of pins=11
** sym_path: design/cp.sym
** sch_path: design/cp.sch
.subckt cp UP DN B0 B1 IBN ICN IBP ICP VOUT VDD VSS
*.ipin UP
*.ipin DN
*.ipin B0
*.ipin B1
*.iopin IBN
*.iopin ICN
*.iopin IBP
*.iopin ICP
*.iopin VOUT
*.iopin VDD
*.iopin VSS
XMBN IBN IBN VSS VSS nfet_03v3 L=1u W=16u nf=1 ad='int((nf+1)/2) * W/nf * 0.18u' as='int((nf+2)/2) * W/nf * 0.18u' pd='2*int((nf+1)/2) * (W/nf + 0.18u)'
+ ps='2*int((nf+2)/2) * (W/nf + 0.18u)' nrd='0.18u / W' nrs='0.18u / W' sa=0 sb=0 sd=0 m=1
XMCN ICN ICN VSS VSS nfet_03v3 L=1u W=4u nf=1 ad='int((nf+1)/2) * W/nf * 0.18u' as='int((nf+2)/2) * W/nf * 0.18u' pd='2*int((nf+1)/2) * (W/nf + 0.18u)'
+ ps='2*int((nf+2)/2) * (W/nf + 0.18u)' nrd='0.18u / W' nrs='0.18u / W' sa=0 sb=0 sd=0 m=1
XMBP IBP IBP VDD VDD pfet_03v3 L=1u W=48u nf=1 ad='int((nf+1)/2) * W/nf * 0.18u' as='int((nf+2)/2) * W/nf * 0.18u' pd='2*int((nf+1)/2) * (W/nf + 0.18u)'
+ ps='2*int((nf+2)/2) * (W/nf + 0.18u)' nrd='0.18u / W' nrs='0.18u / W' sa=0 sb=0 sd=0 m=1
XMCP ICP ICP VDD VDD pfet_03v3 L=1u W=12u nf=1 ad='int((nf+1)/2) * W/nf * 0.18u' as='int((nf+2)/2) * W/nf * 0.18u' pd='2*int((nf+1)/2) * (W/nf + 0.18u)'
+ ps='2*int((nf+2)/2) * (W/nf + 0.18u)' nrd='0.18u / W' nrs='0.18u / W' sa=0 sb=0 sd=0 m=1
xi_b0 B0 B0B VDD VSS pfdcp_inv_3v3
xi_b1 B1 B1B VDD VSS pfdcp_inv_3v3
xi_up UP UPB VDD VSS pfdcp_inv_3v3
xi_dn DN DNB VDD VSS pfdcp_inv_3v3
xn_base IBN ICN VDD VSS DNT VSS cp_leg_n
xn_t0 IBN ICN B0 B0B DNT VSS cp_leg_n
xn_t1a IBN ICN B1 B1B DNT VSS cp_leg_n
xn_t1b IBN ICN B1 B1B DNT VSS cp_leg_n
xp_base IBP ICP VDD VSS UPT VDD cp_leg_p
xp_t0 IBP ICP B0 B0B UPT VDD cp_leg_p
xp_t1a IBP ICP B1 B1B UPT VDD cp_leg_p
xp_t1b IBP ICP B1 B1B UPT VDD cp_leg_p
XMSWDN VOUT DN DNT VSS nfet_03v3 L=0.3u W=6u nf=1 ad='int((nf+1)/2) * W/nf * 0.18u' as='int((nf+2)/2) * W/nf * 0.18u' pd='2*int((nf+1)/2) * (W/nf + 0.18u)'
+ ps='2*int((nf+2)/2) * (W/nf + 0.18u)' nrd='0.18u / W' nrs='0.18u / W' sa=0 sb=0 sd=0 m=1
XMDMPDN VDUMP DNB DNT VSS nfet_03v3 L=0.3u W=6u nf=1 ad='int((nf+1)/2) * W/nf * 0.18u' as='int((nf+2)/2) * W/nf * 0.18u' pd='2*int((nf+1)/2) * (W/nf + 0.18u)'
+ ps='2*int((nf+2)/2) * (W/nf + 0.18u)' nrd='0.18u / W' nrs='0.18u / W' sa=0 sb=0 sd=0 m=1
XMSWUP VOUT UPB UPT VDD pfet_03v3 L=0.3u W=6u nf=1 ad='int((nf+1)/2) * W/nf * 0.18u' as='int((nf+2)/2) * W/nf * 0.18u' pd='2*int((nf+1)/2) * (W/nf + 0.18u)'
+ ps='2*int((nf+2)/2) * (W/nf + 0.18u)' nrd='0.18u / W' nrs='0.18u / W' sa=0 sb=0 sd=0 m=1
XMDMPUP VDUMP UP UPT VDD pfet_03v3 L=0.3u W=6u nf=1 ad='int((nf+1)/2) * W/nf * 0.18u' as='int((nf+2)/2) * W/nf * 0.18u' pd='2*int((nf+1)/2) * (W/nf + 0.18u)'
+ ps='2*int((nf+2)/2) * (W/nf + 0.18u)' nrd='0.18u / W' nrs='0.18u / W' sa=0 sb=0 sd=0 m=1
XMDUMN VOUT DNB VOUT VSS nfet_03v3 L=0.3u W=3u nf=1 ad='int((nf+1)/2) * W/nf * 0.18u' as='int((nf+2)/2) * W/nf * 0.18u' pd='2*int((nf+1)/2) * (W/nf + 0.18u)'
+ ps='2*int((nf+2)/2) * (W/nf + 0.18u)' nrd='0.18u / W' nrs='0.18u / W' sa=0 sb=0 sd=0 m=1
XMDUMP VOUT UP VOUT VDD pfet_03v3 L=0.3u W=3u nf=1 ad='int((nf+1)/2) * W/nf * 0.18u' as='int((nf+2)/2) * W/nf * 0.18u' pd='2*int((nf+1)/2) * (W/nf + 0.18u)'
+ ps='2*int((nf+2)/2) * (W/nf + 0.18u)' nrd='0.18u / W' nrs='0.18u / W' sa=0 sb=0 sd=0 m=1
XMCLPN1 VDUMP VDUMP NCLP VSS nfet_03v3 L=1u W=4u nf=1 ad='int((nf+1)/2) * W/nf * 0.18u' as='int((nf+2)/2) * W/nf * 0.18u' pd='2*int((nf+1)/2) * (W/nf + 0.18u)'
+ ps='2*int((nf+2)/2) * (W/nf + 0.18u)' nrd='0.18u / W' nrs='0.18u / W' sa=0 sb=0 sd=0 m=1
XMCLPN2 NCLP NCLP VSS VSS nfet_03v3 L=1u W=4u nf=1 ad='int((nf+1)/2) * W/nf * 0.18u' as='int((nf+2)/2) * W/nf * 0.18u' pd='2*int((nf+1)/2) * (W/nf + 0.18u)'
+ ps='2*int((nf+2)/2) * (W/nf + 0.18u)' nrd='0.18u / W' nrs='0.18u / W' sa=0 sb=0 sd=0 m=1
XMCLPP1 VDUMP VDUMP PCLP VDD pfet_03v3 L=1u W=12u nf=1 ad='int((nf+1)/2) * W/nf * 0.18u' as='int((nf+2)/2) * W/nf * 0.18u' pd='2*int((nf+1)/2) * (W/nf + 0.18u)'
+ ps='2*int((nf+2)/2) * (W/nf + 0.18u)' nrd='0.18u / W' nrs='0.18u / W' sa=0 sb=0 sd=0 m=1
XMCLPP2 PCLP PCLP VDD VDD pfet_03v3 L=1u W=12u nf=1 ad='int((nf+1)/2) * W/nf * 0.18u' as='int((nf+2)/2) * W/nf * 0.18u' pd='2*int((nf+1)/2) * (W/nf + 0.18u)'
+ ps='2*int((nf+2)/2) * (W/nf + 0.18u)' nrd='0.18u / W' nrs='0.18u / W' sa=0 sb=0 sd=0 m=1
.ends

* expanding   symbol:  edgedet.sym # of pins=4
** sym_path: design/edgedet.sym
** sch_path: design/edgedet.sch
.subckt edgedet X PULSE VDD VSS
*.ipin X
*.opin PULSE
*.iopin VDD
*.iopin VSS
xi1 X D1 VDD VSS pfdcp_inv_3v3
xi2 D1 D2 VDD VSS pfdcp_inv_3v3
xi3 D2 D3 VDD VSS pfdcp_inv_3v3
xi4 D3 D4 VDD VSS pfdcp_inv_3v3
xi5 D4 D5 VDD VSS pfdcp_inv_3v3
xnd X D5 NN VDD VSS pfdcp_nand2_3v3
xi6 NN PULSE VDD VSS pfdcp_inv_3v3
.ends

* expanding   symbol:  pfdcp_inv_3v3.sym # of pins=4
** sym_path: design/pfdcp_inv_3v3.sym
** sch_path: design/pfdcp_inv_3v3.sch
.subckt pfdcp_inv_3v3 A Y VDD VSS
*.ipin A
*.opin Y
*.iopin VDD
*.iopin VSS
XMP Y A VDD VDD pfet_03v3 L=0.3u W=1.5u nf=1 ad='int((nf+1)/2) * W/nf * 0.18u' as='int((nf+2)/2) * W/nf * 0.18u' pd='2*int((nf+1)/2) * (W/nf + 0.18u)'
+ ps='2*int((nf+2)/2) * (W/nf + 0.18u)' nrd='0.18u / W' nrs='0.18u / W' sa=0 sb=0 sd=0 m=1
XMN Y A VSS VSS nfet_03v3 L=0.3u W=0.5u nf=1 ad='int((nf+1)/2) * W/nf * 0.18u' as='int((nf+2)/2) * W/nf * 0.18u' pd='2*int((nf+1)/2) * (W/nf + 0.18u)'
+ ps='2*int((nf+2)/2) * (W/nf + 0.18u)' nrd='0.18u / W' nrs='0.18u / W' sa=0 sb=0 sd=0 m=1
.ends

* expanding   symbol:  srlatch.sym # of pins=6
** sym_path: design/srlatch.sym
** sch_path: design/srlatch.sch
.subckt srlatch SB RB Q QB VDD VSS
*.ipin SB
*.ipin RB
*.opin Q
*.opin QB
*.iopin VDD
*.iopin VSS
xn1 SB QB Q VDD VSS pfdcp_nand2_3v3
xn2 RB Q QB VDD VSS pfdcp_nand2_3v3
.ends

* expanding   symbol:  pfdcp_nand2_3v3.sym # of pins=5
** sym_path: design/pfdcp_nand2_3v3.sym
** sch_path: design/pfdcp_nand2_3v3.sch
.subckt pfdcp_nand2_3v3 A B Y VDD VSS
*.ipin A
*.ipin B
*.opin Y
*.iopin VDD
*.iopin VSS
XMP1 Y A VDD VDD pfet_03v3 L=0.3u W=1.5u nf=1 ad='int((nf+1)/2) * W/nf * 0.18u' as='int((nf+2)/2) * W/nf * 0.18u' pd='2*int((nf+1)/2) * (W/nf + 0.18u)'
+ ps='2*int((nf+2)/2) * (W/nf + 0.18u)' nrd='0.18u / W' nrs='0.18u / W' sa=0 sb=0 sd=0 m=1
XMP2 Y B VDD VDD pfet_03v3 L=0.3u W=1.5u nf=1 ad='int((nf+1)/2) * W/nf * 0.18u' as='int((nf+2)/2) * W/nf * 0.18u' pd='2*int((nf+1)/2) * (W/nf + 0.18u)'
+ ps='2*int((nf+2)/2) * (W/nf + 0.18u)' nrd='0.18u / W' nrs='0.18u / W' sa=0 sb=0 sd=0 m=1
XMN1 Y A NI VSS nfet_03v3 L=0.3u W=1u nf=1 ad='int((nf+1)/2) * W/nf * 0.18u' as='int((nf+2)/2) * W/nf * 0.18u' pd='2*int((nf+1)/2) * (W/nf + 0.18u)'
+ ps='2*int((nf+2)/2) * (W/nf + 0.18u)' nrd='0.18u / W' nrs='0.18u / W' sa=0 sb=0 sd=0 m=1
XMN2 NI B VSS VSS nfet_03v3 L=0.3u W=1u nf=1 ad='int((nf+1)/2) * W/nf * 0.18u' as='int((nf+2)/2) * W/nf * 0.18u' pd='2*int((nf+1)/2) * (W/nf + 0.18u)'
+ ps='2*int((nf+2)/2) * (W/nf + 0.18u)' nrd='0.18u / W' nrs='0.18u / W' sa=0 sb=0 sd=0 m=1
.ends

* expanding   symbol:  cp_leg_n.sym # of pins=6
** sym_path: design/cp_leg_n.sym
** sch_path: design/cp_leg_n.sch
.subckt cp_leg_n VBN VCASCN EN ENB TAIL VSS
*.ipin VBN
*.ipin VCASCN
*.ipin EN
*.ipin ENB
*.iopin TAIL
*.iopin VSS
XMEN BG EN VBN VSS nfet_03v3 L=0.3u W=1u nf=1 ad='int((nf+1)/2) * W/nf * 0.18u' as='int((nf+2)/2) * W/nf * 0.18u' pd='2*int((nf+1)/2) * (W/nf + 0.18u)'
+ ps='2*int((nf+2)/2) * (W/nf + 0.18u)' nrd='0.18u / W' nrs='0.18u / W' sa=0 sb=0 sd=0 m=1
XMDIS BG ENB VSS VSS nfet_03v3 L=0.3u W=1u nf=1 ad='int((nf+1)/2) * W/nf * 0.18u' as='int((nf+2)/2) * W/nf * 0.18u' pd='2*int((nf+1)/2) * (W/nf + 0.18u)'
+ ps='2*int((nf+2)/2) * (W/nf + 0.18u)' nrd='0.18u / W' nrs='0.18u / W' sa=0 sb=0 sd=0 m=1
XMBOT MID BG VSS VSS nfet_03v3 L=1u W=4u nf=1 ad='int((nf+1)/2) * W/nf * 0.18u' as='int((nf+2)/2) * W/nf * 0.18u' pd='2*int((nf+1)/2) * (W/nf + 0.18u)'
+ ps='2*int((nf+2)/2) * (W/nf + 0.18u)' nrd='0.18u / W' nrs='0.18u / W' sa=0 sb=0 sd=0 m=1
XMCASC TAIL VCASCN MID VSS nfet_03v3 L=1u W=4u nf=1 ad='int((nf+1)/2) * W/nf * 0.18u' as='int((nf+2)/2) * W/nf * 0.18u' pd='2*int((nf+1)/2) * (W/nf + 0.18u)'
+ ps='2*int((nf+2)/2) * (W/nf + 0.18u)' nrd='0.18u / W' nrs='0.18u / W' sa=0 sb=0 sd=0 m=1
.ends

* expanding   symbol:  cp_leg_p.sym # of pins=6
** sym_path: design/cp_leg_p.sym
** sch_path: design/cp_leg_p.sch
.subckt cp_leg_p VBP VCASCP EN ENB TAIL VDD
*.ipin VBP
*.ipin VCASCP
*.ipin EN
*.ipin ENB
*.iopin TAIL
*.iopin VDD
XMEN BG ENB VBP VDD pfet_03v3 L=0.3u W=1u nf=1 ad='int((nf+1)/2) * W/nf * 0.18u' as='int((nf+2)/2) * W/nf * 0.18u' pd='2*int((nf+1)/2) * (W/nf + 0.18u)'
+ ps='2*int((nf+2)/2) * (W/nf + 0.18u)' nrd='0.18u / W' nrs='0.18u / W' sa=0 sb=0 sd=0 m=1
XMDIS BG EN VDD VDD pfet_03v3 L=0.3u W=1u nf=1 ad='int((nf+1)/2) * W/nf * 0.18u' as='int((nf+2)/2) * W/nf * 0.18u' pd='2*int((nf+1)/2) * (W/nf + 0.18u)'
+ ps='2*int((nf+2)/2) * (W/nf + 0.18u)' nrd='0.18u / W' nrs='0.18u / W' sa=0 sb=0 sd=0 m=1
XMTOP MID BG VDD VDD pfet_03v3 L=1u W=12u nf=1 ad='int((nf+1)/2) * W/nf * 0.18u' as='int((nf+2)/2) * W/nf * 0.18u' pd='2*int((nf+1)/2) * (W/nf + 0.18u)'
+ ps='2*int((nf+2)/2) * (W/nf + 0.18u)' nrd='0.18u / W' nrs='0.18u / W' sa=0 sb=0 sd=0 m=1
XMCASC TAIL VCASCP MID VDD pfet_03v3 L=1u W=12u nf=1 ad='int((nf+1)/2) * W/nf * 0.18u' as='int((nf+2)/2) * W/nf * 0.18u' pd='2*int((nf+1)/2) * (W/nf + 0.18u)'
+ ps='2*int((nf+2)/2) * (W/nf + 0.18u)' nrd='0.18u / W' nrs='0.18u / W' sa=0 sb=0 sd=0 m=1
.ends
