* gf180-pll :: pll-top-smoke :: closed-loop cold-start acquisition smoke test
*
* DUT: `pll_top` -- the whole PLL, from design/pll_top.sch, netlisted by
* design/netlist.sh into design/netlist/pll_top.spice and prepended to this
* fragment by sim/lib/assemble_closed_loop.sh.  Nothing here is a
* hand-transcribed copy of the design: a schematic edit this deck does not
* track is a netlist error, not a silently divergent second top level.  That
* single-owner property is the whole point of #52.
*
* WHAT THIS RECORD IS FOR, AND WHAT IT IS NOT.
* This is the ACCEPTANCE GATE for the top-level assembly: it proves that the
* five independently characterised blocks, wired together as pll_top, form a
* loop that acquires and holds lock at one nominal operating point.  It is a
* SMOKE test by construction -- one corner, one N, one band, cold start.  The
* full closed-loop campaigns stay where they belong:
*   #12  sim/lock-time, sim/output-range   lock time and band coverage over PVT
*   #13  sim/period-jitter                 jitter
*   #14  sim/supply-sensitivity            supply pushing and power
* A number from this deck is not a substitute for any of them, and the record
* it mints says so in its own Corner matrix and Limitations fields.
*
* Expects from the generated header (sim/lib/simenv.sh):
*   .lib <corner sections>   .temp <temp_c>   .param vsup=<volts>
* and from the runner, one .param each:
*   fref        reference frequency, Hz
*   nratio      the divide ratio the SEL/P bits below encode (used only to
*               state the expected output frequency; the bits are what the
*               divider actually sees)
*   b*_code     VCO band select bits          (sim/lib/assemble_closed_loop.sh)
*   cpb*_code   charge-pump Icp trim bits     (   "   )
*   sel*_code, p*_code   divider chain-length / modulus bits   (   "   )
*   tstop       transient length
*   ta, tb      the two late measurement instants (see "Lock criterion")
*   tstep, tmax transient step controls

*--------------------------------------------------------------- stimulus ---
* Charge-pump bias references.  Four ideal sources at 4x the unit-leg current,
* exactly as sim/devchar-cp, sim/pfd-deadzone and sim/cp-compliance drive them:
* the bias generator is a separate, not-yet-designed block (design/README.md,
* "Bias generation is out of scope for this block"), so driving these ideally
* keeps the measured behaviour the LOOP's own rather than folding in a
* reference whose mismatch has no design behind it yet.
.param iunit=8u

* Reference clock.  200 ps edges rather than an ideal step, for the same
* reason sim/pfd-deadzone uses them: a zero-rise-time stimulus flatters every
* delay in the PFD's set path.
.param tref='1/fref'
.param tstart='0.5*tref'

vvdd     vdd     0 dc 'vsup'
vvddvco  vdd_vco 0 dc 'vsup'
vvdddiv  vdd_div 0 dc 'vsup'
vgndvco  gnd_vco 0 dc 0
vvss     vss     0 dc 0

vref ref 0 pulse(0 'vsup' 'tstart' 200p 200p '0.5*tref' 'tref')

* Static configuration.  Every one of these is a real pin on the block: DR-001
* Decision 2 keeps band select a static input with no calibration FSM, and
* DR-001 Decision 3 does the same for N.
vb0   b0   0 dc 'vsup*b0_code'
vb1   b1   0 dc 'vsup*b1_code'
vb2   b2   0 dc 'vsup*b2_code'
vcpb0 cpb0 0 dc 'vsup*cpb0_code'
vcpb1 cpb1 0 dc 'vsup*cpb1_code'
vp0   p0   0 dc 'vsup*p0_code'
vp1   p1   0 dc 'vsup*p1_code'
vp2   p2   0 dc 'vsup*p2_code'
vp3   p3   0 dc 'vsup*p3_code'
vp4   p4   0 dc 'vsup*p4_code'
vp5   p5   0 dc 'vsup*p5_code'
vs0   sel0 0 dc 'vsup*sel0_code'
vs1   sel1 0 dc 'vsup*sel1_code'
vs2   sel2 0 dc 'vsup*sel2_code'
vs3   sel3 0 dc 'vsup*sel3_code'
vs4   sel4 0 dc 'vsup*sel4_code'
vs5   sel5 0 dc 'vsup*sel5_code'

iibn vdd ibn dc 'iunit'
iicn vdd icn dc 'iunit'
iibp ibp 0   dc 'iunit'
iicp icp 0   dc 'iunit'

* The DUT.  This instance line is generated by
* sim/lib/assemble_closed_loop.sh's `cloop_instance`, so the 32-port order is
* never transcribed by hand in a campaign.
xdut ref b0 b1 b2 cpb0 cpb1 p0 p1 p2 p3 p4 p5 sel0 sel1 sel2 sel3 sel4 sel5
+ ibn icn ibp icp clk divout fb lock vctrl vdd vdd_vco gnd_vco vdd_div vss
+ pll_top

*--------------------------------------------------------- initial state ---
* COLD START.  The control node begins at 0 V, i.e. the VCO begins at its
* floor frequency (the fixed VFIX branch of the V->I converter, well below
* N*fref), and the loop has to pump the control node up to its lock point on
* its own.  This is the acquisition the record claims, not a small-signal
* settling from a helpfully-chosen starting point.
.ic v(vctrl)=0

* Break the ring's DC symmetry so the operating point is not the metastable
* all-nodes-at-mid solution.  Same constraint sim/vco-tuning-range applies,
* and released the same way when the transient starts.  `uic` is deliberately
* NOT used: the VCO's constant-gm bias generator must be solved to its
* operating point before t=0, or the first microseconds of the run would be a
* bias start-up transient masquerading as loop acquisition.
.ic v(xdut.xvco.y1)=0 v(xdut.xvco.y2)='vsup' v(xdut.xvco.y3)=0
+ v(xdut.xvco.y4)='vsup' v(xdut.xvco.y5)=0

*---------------------------------------------------------------- analysis ---
* rshunt: the charge pump's disabled trim legs leave their cascode mid-node
* driven only by two off devices -- a floating node for the DC operating
* point.  Same 1 Tohm shunt sim/pfd-deadzone uses, for the same reason; at
* 3.3 V it is 3.3 pA against a multi-microamp signal.
* itl4: transient Newton-iteration limit, a solver-EFFORT knob.  Every
* convergence TOLERANCE is left alone, so the converged solution is unchanged;
* the dump-node buffer (cp_dumpbuf, DR-005) puts two MOS gates on the control
* node and the iteration count matters for the same reason it does in
* sim/pfd-deadzone.
.option rshunt=1e12 itl4=200 reltol=1e-3 abstol=1e-13 vntol=1e-6

* The transient is issued from the .control block at the bottom, NOT from a
* top-level `.tran` card, and that is load-bearing rather than stylistic: with
* BOTH present, ngspice batch mode runs the control block's analysis and then
* runs the top-level card again -- two full transients, double the wall clock,
* for one record.  The `.meas` cards below still evaluate against the control
* block's run (measurements are attached to the analysis, not to the card that
* launched it), so this deck keeps the readable top-level `.meas` style every
* other campaign here uses.  `.csparam` is how the .param values reach the
* control block, the same mechanism sim/pfd-deadzone uses for `vsup`.
.csparam c_tstep={tstep}
.csparam c_tstop={tstop}
.csparam c_tmax={tmax}

*-------------------------------------------------------------- lock criterion
* The loop is LOCKED when both of these hold:
*
*   (a) FREQUENCY.  The static phase error between REF and the retimed
*       feedback edge FB does not DRIFT.  In a type-II loop a residual
*       frequency error shows up as a phase that slips linearly, at exactly
*       (df/f) seconds per second, so measuring the REF->FB delay at two
*       instants ta and tb and differencing it gives the residual fractional
*       frequency error directly -- with no dependence on how many cycles
*       ngspice happened to put between them, and to picosecond resolution
*       rather than to the resolution of a period measurement.
*   (b) PHASE.  That static phase error is itself small compared with a
*       reference period.
*
* ta and tb are chosen by the runner to land on the HALF-period of the
* reference (tstart + (k + 0.5)*tref), so the "first REF rise after ta" and
* the "first FB rise after ta" are unambiguously the same cycle's pair and the
* measurement cannot alias by a whole reference period.
.meas tran phi_a trig v(ref) val='vsup/2' rise=1 td='ta' targ v(fb) val='vsup/2' rise=1 td='ta'
.meas tran phi_b trig v(ref) val='vsup/2' rise=1 td='tb' targ v(fb) val='vsup/2' rise=1 td='tb'
.meas tran dphi   param='phi_b-phi_a'
.meas tran ferr   param='-(phi_b-phi_a)/(tb-ta)'

* Output frequency, over 160 whole VCO cycles inside the late window -- a
* fixed cycle COUNT rather than a fixed time, so the same deck measures the
* same way at any N.
.meas tran tclk160 trig v(clk) val='vsup/2' rise=1 td='tb' targ v(clk) val='vsup/2' rise=161 td='tb'
.meas tran fout param='160/tclk160'

* Feedback frequency over 20 whole FB cycles: must be fref.  Measured
* independently of fout so a divider that is dividing by the wrong N shows up
* as fout/ffb != nratio rather than hiding inside a single ratio.
.meas tran tfb20 trig v(fb) val='vsup/2' rise=1 td='tb' targ v(fb) val='vsup/2' rise=21 td='tb'
.meas tran ffb param='20/tfb20'
.meas tran nmeas param='fout/ffb'

* Control node: settled value, and the peak-to-peak ripple on it in the late
* window.  Ripple is the reference-spur mechanism #14 owns; it is reported
* here as a sanity number, not as a spur claim.
.meas tran vctrl_avg avg v(vctrl) from='tb' to='tstop'
.meas tran vctrl_min min v(vctrl) from='tb' to='tstop'
.meas tran vctrl_max max v(vctrl) from='tb' to='tstop'
.meas tran vctrl_ini find v(vctrl) at='tstart'

* The block's own LOCK flag (#11's window comparator), read two ways: when it
* first asserts, and its average level in the late window -- so a flag that is
* chattering shows up as a fractional average rather than being rounded to a
* verdict.
.meas tran t_lock when v(lock)='vsup/2' rise=1
.meas tran lock_lvl avg v(lock) from='tb' to='tstop'

* Supply currents per domain, averaged over the late window.  A power number
* at one corner is not the #14 claim; it is here because a loop that "locks"
* while drawing an implausible current is not actually working.
.meas tran i_ref avg i(vvdd)    from='tb' to='tstop'
.meas tran i_vco avg i(vvddvco) from='tb' to='tstop'
.meas tran i_div avg i(vvdddiv) from='tb' to='tstop'

*------------------------------------------------------------------ waveform
* The acquisition transient IS part of the evidence here, so it is retained --
* but as a CSV of the three signals that carry the argument (the control node,
* the lock flag, and the feedback edge), never as a rawfile.  This writes the
* full-resolution trace into the run directory; the runner decimates it to the
* committed artifact and states the decimation in the record, per
* sim/README.md's "Waveform rule".  Decimating in the runner rather than with
* ngspice's `linearize` is deliberate: `linearize` builds a second plot and
* every `.meas` above is then re-evaluated against the RESAMPLED data, so the
* log would carry two different values for each measurement and a reader would
* have to know which one to trust.
.control
  set noaskquit
  tran $&c_tstep $&c_tstop 0 $&c_tmax
  wrdata lock_transient_full.csv v(vctrl) v(lock) v(fb)
.endc
