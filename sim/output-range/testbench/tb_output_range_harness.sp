* gf180-pll :: output-range :: closed-loop output-band coverage testbench,
* HARNESS FORM (#878)
*
* This is tb_output_range.sp re-expressed as a sim/harness fragment, so the
* campaign runs through `python3 sim/run_corners.py output-range` (and its
* `--backend batch`) instead of through the hand-rolled run.sh fan-out.  The
* stimulus, topology, static configuration, SWFORCE release clamp, initial
* conditions and every convergence tolerance are the committed deck's own;
* only the mechanical differences below changed.  run.sh and the old deck
* are kept unmodified except for run.sh's SUPERSEDED banner.
*
* WHAT CHANGED, AND WHY EACH IS MECHANICAL
*   - `vsup` -> the harness's `vdd_val` (a `.param vsup` alias keeps the
*     remaining expressions byte-identical).
*   - The per-row values run.sh computed in bash and passed as `.param`
*     overrides (fref, vctrl_ic, band/divider/trim codes, the transient
*     controls) arrive from tb.json's `op` sweep axis, one point per
*     (PVT point, edge) row.  They are generated, not hand-typed, by
*     gen_tb_json.py in this directory, which calls run.sh's own
*     `seed_for_corner` and sim/lib/pll_top_dut.sh's `cloop_*` encoders.
*   - The `.measure` cards, the `.control` block and the `.options` card are
*     the harness's to write: tb.json's `raw_measures`, `analyses` and
*     `options` carry the same measurements, the same single transient
*     (`tran tstep tstop 0 tmax`, tmax = 100 ps, #65) and the same options.
*   - The `waveform.csv` capture of the old deck is NOT reproduced (the
*     campaign's reduction never read it).
*
* Expects from the harness: vdd_val, temp_c; from tb.json: fref, vctrl_ic,
* ktforce, ktstep, ktstop, ktmax, b*_code, cpb*_code, ldt*_code,
* sel*_code, p*_code.

.param vsup='vdd_val'
.param lockthresh='0.5*vsup'
.param iunit=8u

*------------------------------------------------------------------ supplies
vvdd    vdd     0 dc 'vdd_val'
vvddvco vdd_vco 0 dc 'vdd_val'
vvdddiv vdd_div 0 dc 'vdd_val'
vgndvco gnd_vco 0 dc 0
vvss    vss     0 dc 0

*----------------------------------------------------------- reference clock
vref ref 0 pulse(0 'vdd_val' 20n 200p 200p '0.5/fref-200p' '1/fref')

*----------------------------------------------------- static configuration
* Encoded by sim/lib/pll_top_dut.sh (cloop_band_params / cloop_trim_params /
* cloop_divider_params), not by this deck -- see tb_lock_time.sp's header.
vb0   b0   0 dc 'vdd_val*b0_code'
vb1   b1   0 dc 'vdd_val*b1_code'
vb2   b2   0 dc 'vdd_val*b2_code'
vcpb0 cpb0 0 dc 'vdd_val*cpb0_code'
vcpb1 cpb1 0 dc 'vdd_val*cpb1_code'

* Lock-detector window trim (DR-014, #411): a 4-bit STATIC process trim,
* set once at test and held for the life of the part, so it is a DC source
* like the band and Icp codes beside it and never changes inside a run.
* The code this deck runs at comes from the campaign's own runner/manifest
* (sim/lib/pll_top_dut.sh's cloop_window_trim_params), not from here.
vldt0 ldt0 0 dc 'vdd_val*ldt0_code'
vldt1 ldt1 0 dc 'vdd_val*ldt1_code'
vldt2 ldt2 0 dc 'vdd_val*ldt2_code'
vldt3 ldt3 0 dc 'vdd_val*ldt3_code'

vp0   p0   0 dc 'vdd_val*p0_code'
vp1   p1   0 dc 'vdd_val*p1_code'
vp2   p2   0 dc 'vdd_val*p2_code'
vp3   p3   0 dc 'vdd_val*p3_code'
vp4   p4   0 dc 'vdd_val*p4_code'
vp5   p5   0 dc 'vdd_val*p5_code'
vs0   sel0 0 dc 'vdd_val*sel0_code'
vs1   sel1 0 dc 'vdd_val*sel1_code'
vs2   sel2 0 dc 'vdd_val*sel2_code'
vs3   sel3 0 dc 'vdd_val*sel3_code'
vs4   sel4 0 dc 'vdd_val*sel4_code'
vs5   sel5 0 dc 'vdd_val*sel5_code'

iibn vdd ibn dc 'iunit'
iicn vdd icn dc 'iunit'
iibp ibp 0 dc 'iunit'
iicp icp 0 dc 'iunit'

*--------------------------------------------------------------------- DUT
* Generated by sim/lib/pll_top_dut.sh's `cloop_instance`.
xdut ref b0 b1 b2 cpb0 cpb1 ldt0 ldt1 ldt2 ldt3 p0 p1 p2 p3 p4 p5 sel0 sel1 sel2 sel3 sel4 sel5
+ ibn icn ibp icp clk divout fb lock vctrl vdd vdd_vco gnd_vco vdd_div vss
+ pll_top

.ic v(xdut.xvco.y1)=0 v(xdut.xvco.y2)='vdd_val' v(xdut.xvco.y3)=0
+ v(xdut.xvco.y4)='vdd_val' v(xdut.xvco.y5)=0

* Released clamp seeding VCTRL near run.sh's open-loop estimate of the
* locked value (see header comment above and this record's Methodology) --
* same mechanism as tb_lock_time.sp.
vsetv vsetnode 0 dc 'vctrl_ic'
* Release transition sized as a multiple of the internal-timestep ceiling
* (#65) -- same fix as tb_lock_time.sp's identical mechanism, applied here
* preemptively for the same root cause: at the OLD 100 ps tr/tf (equal to
* the 100 ps ceiling), the switch's Ron(10)/Roff(1G) discontinuity spans
* exactly one ceiling-sized step, which sim/lock-time's cold-start row
* (vctrl_ic=0.9V, at a rail) showed ngspice cannot resolve -- "Timestep too
* small", 100% reproducible, independent of corner or host load. This bench
* was NOT observed to reproduce the crash at its one checked point
* (typical/27C/3.30V, `lo` edge, vctrl_ic ~1.68V mid-window rather than at a
* rail) before this fix landed, but shares the identical model/mechanism, so
* the fix is applied defensively rather than waiting for a corner where the
* discontinuity happens to be sharp enough to fail. See this campaign's
* sibling investigation record (sim/lock-time) for the full root-cause.
vsctrl sctrl 0 pulse('vdd_val' 0 'ktforce' '10*ktmax' '10*ktmax' '2*ktstop' '4*ktstop')
sforce vctrl vsetnode sctrl 0 SWFORCE
.model SWFORCE SW(Ron=10 Roff=1G Vt='vdd_val/2' Vh=0)

* Lock-detector level the `.measure`s in tb.json threshold against is
* 0.5*vdd_val (== lockthresh above, as in the committed deck).
