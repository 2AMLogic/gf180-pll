* gf180-pll :: vco-tuning-range :: supply-step and supply-ripple jitter
*
* DR-001's Consequences section names supply noise the accepted risk of the
* current-starved single-ended ring, and names this testbench as the evidence
* #8 owes: "a supply-step/supply-noise jitter testbench, not just a clean-supply
* Kvco sweep. This is the number most likely to force a supersede."
*
* DUT: design/vco.sch, exported by design/netlist.sh and frozen per record as
* sim/vco-tuning-range/netlist-snapshots/<record-id>.spice. The runner copies
* that snapshot into the run directory as vco.spice.
*
* Measurement topology -- three independent copies of the whole VCO at one PVT
* point, one band code and one control voltage, differing ONLY in what drives
* their supply rail:
*
*   XQ  quiet rail, dc vsup. This copy is the **numerical noise floor**: any
*       cycle-to-cycle variation it shows is the transient solver's own local
*       truncation error, not circuit behaviour. Every jitter number from the
*       other two copies is reported against this floor, so the record can say
*       whether the supply-induced jitter is resolvable at all.
*   XS  rail with a single fast STEP of `astep` volts at t = `tstepon`,
*       `tedge` edge. Gives the transient supply-pushing coefficient (which is
*       not assumed equal to the dc one) and the timing error a supply droop
*       accumulates while the loop has not yet corrected it.
*   XR  rail with a sinusoidal RIPPLE of amplitude `arip` at `frip`. Gives
*       peak-to-peak / RMS period jitter and the peak-to-peak time interval
*       error (TIE), which is the quantity a jitter budget actually consumes.
*
* Each copy's 3-bit band code is generated by a VCVS from that copy's own rail,
* so the static band-select code tracks the perturbed supply exactly rather
* than presenting a stale logic level to the band-select pass gates.
*
* No `.meas` is used. The three buffered outputs are written to `jit.dat` and
* every reported number is extracted from interpolated half-supply crossings by
* analyze_supply.py -- `.meas` cannot report a per-cycle period sequence, and
* the period *sequence* is what jitter is.
*
* Expects from the generated header (see sim/lib/simenv.sh):
*   .lib <mos corner> / <res corner> / <moscap corner> sections
*   .temp <temp_c>
*   .param vsup vctrl b0 b1 b2
*   .param astep tstepon tedge arip frip
*   .param tstop tstep tmax tsettle
*
* Devices are PDK 3.3 V thick-oxide wrappers only (DR-002 Decision 3).

.include "vco.spice"

* Tighter than the ngspice default (1e-3) so the quiet copy's numerical jitter
* floor sits well below the supply-induced jitter being measured.
.options reltol=1e-4

vc vctl 0 dc 'vctrl'

*----------------------------------------------------- XQ: quiet reference rail
vq nq 0 dc 'vsup'
eqa qa 0 nq 0 'b0'
eqb qb 0 nq 0 'b1'
eqc qc 0 nq 0 'b2'
xq vctl qa qb qc clkq nq 0 vco

*---------------------------------------------------------- XS: supply step
vsd nsd 0 dc 'vsup'
vst nst nsd pulse(0 'astep' 'tstepon' 'tedge' 'tedge' 1 2)
esa sa 0 nst 0 'b0'
esb sb 0 nst 0 'b1'
esc sc 0 nst 0 'b2'
xs vctl sa sb sc clks nst 0 vco

*--------------------------------------------------------- XR: supply ripple
vrd nrd 0 dc 'vsup'
vrp nrp nrd sin(0 'arip' 'frip')
era ra 0 nrp 0 'b0'
erb rb 0 nrp 0 'b1'
erc rc 0 nrp 0 'b2'
xr vctl ra rb rc clkr nrp 0 vco

* Break the ring's metastable all-nodes-at-mid DC solution. `uic` is NOT used:
* every bias generator is solved to its operating point before t=0.
.ic v(xq.Y1)=0 v(xq.Y2)='vsup' v(xq.Y3)=0 v(xq.Y4)='vsup' v(xq.Y5)=0
.ic v(xs.Y1)=0 v(xs.Y2)='vsup' v(xs.Y3)=0 v(xs.Y4)='vsup' v(xs.Y5)=0
.ic v(xr.Y1)=0 v(xr.Y2)='vsup' v(xr.Y3)=0 v(xr.Y4)='vsup' v(xr.Y5)=0

.tran 'tstep' 'tstop' 0 'tmax'

.control
run
set wr_singlescale
wrdata jit.dat v(clkq) v(clks) v(clkr)
.endc
