* gf180-pll :: div23_cell -- generated by design/netlist.sh from div23_cell.sch
* xschem XSCHEM V3.4.7; do not edit by hand.
** sch_path: /Users/rwalters/GitHub/gf180-pll/.loom/worktrees/issue-11/design/div23_cell.sch
.subckt div23_cell CKIN MODIN P CKOUT MODOUT VDD VSS
*.ipin CKIN
*.ipin MODIN
*.ipin P
*.opin CKOUT
*.opin MODOUT
*.iopin VDD
*.iopin VSS
XN3 MODIN P MODOUT SB VDD VSS nand3_3v3
XN2Q QB SB DQN VDD VSS nand2_3v3
XIQ DQN DQ VDD VSS inv_3v3
XFQ DQ CKIN Q QB VDD VSS dff_tg_3v3
XICKO QB CKOUT VDD VSS inv2x_3v3
XN2M MODIN Q NMO VDD VSS nand2_3v3
XIM NMO DMO VDD VSS inv_3v3
XFMO DMO CKIN MODOUT MOB VDD VSS dff_tg_3v3
.ends

* expanding   symbol:  nand3_3v3.sym # of pins=6
** sym_path: /Users/rwalters/GitHub/gf180-pll/.loom/worktrees/issue-11/design/nand3_3v3.sym
** sch_path: /Users/rwalters/GitHub/gf180-pll/.loom/worktrees/issue-11/design/nand3_3v3.sch
.subckt nand3_3v3 A B C Y VDD VSS
*.ipin A
*.ipin B
*.ipin C
*.opin Y
*.iopin VDD
*.iopin VSS
XMPA Y A VDD VDD pfet_03v3 L=0.28u W=2.5u nf=1 ad='int((nf+1)/2) * W/nf * 0.18u' as='int((nf+2)/2) * W/nf * 0.18u' pd='2*int((nf+1)/2) * (W/nf + 0.18u)'
+ ps='2*int((nf+2)/2) * (W/nf + 0.18u)' nrd='0.18u / W' nrs='0.18u / W' sa=0 sb=0 sd=0 m=1
XMPB Y B VDD VDD pfet_03v3 L=0.28u W=2.5u nf=1 ad='int((nf+1)/2) * W/nf * 0.18u' as='int((nf+2)/2) * W/nf * 0.18u' pd='2*int((nf+1)/2) * (W/nf + 0.18u)'
+ ps='2*int((nf+2)/2) * (W/nf + 0.18u)' nrd='0.18u / W' nrs='0.18u / W' sa=0 sb=0 sd=0 m=1
XMPC Y C VDD VDD pfet_03v3 L=0.28u W=2.5u nf=1 ad='int((nf+1)/2) * W/nf * 0.18u' as='int((nf+2)/2) * W/nf * 0.18u' pd='2*int((nf+1)/2) * (W/nf + 0.18u)'
+ ps='2*int((nf+2)/2) * (W/nf + 0.18u)' nrd='0.18u / W' nrs='0.18u / W' sa=0 sb=0 sd=0 m=1
XMNA Y A NM1 VSS nfet_03v3 L=0.28u W=3u nf=1 ad='int((nf+1)/2) * W/nf * 0.18u' as='int((nf+2)/2) * W/nf * 0.18u' pd='2*int((nf+1)/2) * (W/nf + 0.18u)'
+ ps='2*int((nf+2)/2) * (W/nf + 0.18u)' nrd='0.18u / W' nrs='0.18u / W' sa=0 sb=0 sd=0 m=1
XMNB NM1 B NM2 VSS nfet_03v3 L=0.28u W=3u nf=1 ad='int((nf+1)/2) * W/nf * 0.18u' as='int((nf+2)/2) * W/nf * 0.18u' pd='2*int((nf+1)/2) * (W/nf + 0.18u)'
+ ps='2*int((nf+2)/2) * (W/nf + 0.18u)' nrd='0.18u / W' nrs='0.18u / W' sa=0 sb=0 sd=0 m=1
XMNC NM2 C VSS VSS nfet_03v3 L=0.28u W=3u nf=1 ad='int((nf+1)/2) * W/nf * 0.18u' as='int((nf+2)/2) * W/nf * 0.18u' pd='2*int((nf+1)/2) * (W/nf + 0.18u)'
+ ps='2*int((nf+2)/2) * (W/nf + 0.18u)' nrd='0.18u / W' nrs='0.18u / W' sa=0 sb=0 sd=0 m=1
.ends

* expanding   symbol:  nand2_3v3.sym # of pins=5
** sym_path: /Users/rwalters/GitHub/gf180-pll/.loom/worktrees/issue-11/design/nand2_3v3.sym
** sch_path: /Users/rwalters/GitHub/gf180-pll/.loom/worktrees/issue-11/design/nand2_3v3.sch
.subckt nand2_3v3 A B Y VDD VSS
*.ipin A
*.ipin B
*.opin Y
*.iopin VDD
*.iopin VSS
XMPA Y A VDD VDD pfet_03v3 L=0.28u W=2.5u nf=1 ad='int((nf+1)/2) * W/nf * 0.18u' as='int((nf+2)/2) * W/nf * 0.18u' pd='2*int((nf+1)/2) * (W/nf + 0.18u)'
+ ps='2*int((nf+2)/2) * (W/nf + 0.18u)' nrd='0.18u / W' nrs='0.18u / W' sa=0 sb=0 sd=0 m=1
XMPB Y B VDD VDD pfet_03v3 L=0.28u W=2.5u nf=1 ad='int((nf+1)/2) * W/nf * 0.18u' as='int((nf+2)/2) * W/nf * 0.18u' pd='2*int((nf+1)/2) * (W/nf + 0.18u)'
+ ps='2*int((nf+2)/2) * (W/nf + 0.18u)' nrd='0.18u / W' nrs='0.18u / W' sa=0 sb=0 sd=0 m=1
XMNA Y A NMID VSS nfet_03v3 L=0.28u W=2u nf=1 ad='int((nf+1)/2) * W/nf * 0.18u' as='int((nf+2)/2) * W/nf * 0.18u' pd='2*int((nf+1)/2) * (W/nf + 0.18u)'
+ ps='2*int((nf+2)/2) * (W/nf + 0.18u)' nrd='0.18u / W' nrs='0.18u / W' sa=0 sb=0 sd=0 m=1
XMNB NMID B VSS VSS nfet_03v3 L=0.28u W=2u nf=1 ad='int((nf+1)/2) * W/nf * 0.18u' as='int((nf+2)/2) * W/nf * 0.18u' pd='2*int((nf+1)/2) * (W/nf + 0.18u)'
+ ps='2*int((nf+2)/2) * (W/nf + 0.18u)' nrd='0.18u / W' nrs='0.18u / W' sa=0 sb=0 sd=0 m=1
.ends

* expanding   symbol:  inv_3v3.sym # of pins=4
** sym_path: /Users/rwalters/GitHub/gf180-pll/.loom/worktrees/issue-11/design/inv_3v3.sym
** sch_path: /Users/rwalters/GitHub/gf180-pll/.loom/worktrees/issue-11/design/inv_3v3.sch
.subckt inv_3v3 A Y VDD VSS
*.ipin A
*.opin Y
*.iopin VDD
*.iopin VSS
XMP Y A VDD VDD pfet_03v3 L=0.28u W=2.5u nf=1 ad='int((nf+1)/2) * W/nf * 0.18u' as='int((nf+2)/2) * W/nf * 0.18u' pd='2*int((nf+1)/2) * (W/nf + 0.18u)'
+ ps='2*int((nf+2)/2) * (W/nf + 0.18u)' nrd='0.18u / W' nrs='0.18u / W' sa=0 sb=0 sd=0 m=1
XMN Y A VSS VSS nfet_03v3 L=0.28u W=1u nf=1 ad='int((nf+1)/2) * W/nf * 0.18u' as='int((nf+2)/2) * W/nf * 0.18u' pd='2*int((nf+1)/2) * (W/nf + 0.18u)'
+ ps='2*int((nf+2)/2) * (W/nf + 0.18u)' nrd='0.18u / W' nrs='0.18u / W' sa=0 sb=0 sd=0 m=1
.ends

* expanding   symbol:  dff_tg_3v3.sym # of pins=6
** sym_path: /Users/rwalters/GitHub/gf180-pll/.loom/worktrees/issue-11/design/dff_tg_3v3.sym
** sch_path: /Users/rwalters/GitHub/gf180-pll/.loom/worktrees/issue-11/design/dff_tg_3v3.sch
.subckt dff_tg_3v3 D CK Q QB VDD VSS
*.ipin D
*.ipin CK
*.opin Q
*.opin QB
*.iopin VDD
*.iopin VSS
XICKB CK CKB VDD VSS inv_3v3
XICKBB CKB CKBB VDD VSS inv_3v3
XTGMI D NM CKB CKBB VDD VSS tgate_3v3
XIA NM NMA VDD VSS inv_3v3
XIB NMA NMB VDD VSS inv_3v3
XTGMF NMB NM CKBB CKB VDD VSS tgate_3v3
XTGSI NMA NS CKBB CKB VDD VSS tgate_3v3
XIC NS Q VDD VSS inv_3v3
XID Q QB VDD VSS inv_3v3
XTGSF QB NS CKB CKBB VDD VSS tgate_3v3
.ends

* expanding   symbol:  inv2x_3v3.sym # of pins=4
** sym_path: /Users/rwalters/GitHub/gf180-pll/.loom/worktrees/issue-11/design/inv2x_3v3.sym
** sch_path: /Users/rwalters/GitHub/gf180-pll/.loom/worktrees/issue-11/design/inv2x_3v3.sch
.subckt inv2x_3v3 A Y VDD VSS
*.ipin A
*.opin Y
*.iopin VDD
*.iopin VSS
XMP Y A VDD VDD pfet_03v3 L=0.28u W=5u nf=1 ad='int((nf+1)/2) * W/nf * 0.18u' as='int((nf+2)/2) * W/nf * 0.18u' pd='2*int((nf+1)/2) * (W/nf + 0.18u)'
+ ps='2*int((nf+2)/2) * (W/nf + 0.18u)' nrd='0.18u / W' nrs='0.18u / W' sa=0 sb=0 sd=0 m=1
XMN Y A VSS VSS nfet_03v3 L=0.28u W=2u nf=1 ad='int((nf+1)/2) * W/nf * 0.18u' as='int((nf+2)/2) * W/nf * 0.18u' pd='2*int((nf+1)/2) * (W/nf + 0.18u)'
+ ps='2*int((nf+2)/2) * (W/nf + 0.18u)' nrd='0.18u / W' nrs='0.18u / W' sa=0 sb=0 sd=0 m=1
.ends

* expanding   symbol:  tgate_3v3.sym # of pins=6
** sym_path: /Users/rwalters/GitHub/gf180-pll/.loom/worktrees/issue-11/design/tgate_3v3.sym
** sch_path: /Users/rwalters/GitHub/gf180-pll/.loom/worktrees/issue-11/design/tgate_3v3.sch
.subckt tgate_3v3 A Y GN GP VDD VSS
*.iopin A
*.iopin Y
*.ipin GN
*.ipin GP
*.iopin VDD
*.iopin VSS
XMP Y GP A VDD pfet_03v3 L=0.28u W=2.5u nf=1 ad='int((nf+1)/2) * W/nf * 0.18u' as='int((nf+2)/2) * W/nf * 0.18u' pd='2*int((nf+1)/2) * (W/nf + 0.18u)'
+ ps='2*int((nf+2)/2) * (W/nf + 0.18u)' nrd='0.18u / W' nrs='0.18u / W' sa=0 sb=0 sd=0 m=1
XMN A GN Y VSS nfet_03v3 L=0.28u W=1u nf=1 ad='int((nf+1)/2) * W/nf * 0.18u' as='int((nf+2)/2) * W/nf * 0.18u' pd='2*int((nf+1)/2) * (W/nf + 0.18u)'
+ ps='2*int((nf+2)/2) * (W/nf + 0.18u)' nrd='0.18u / W' nrs='0.18u / W' sa=0 sb=0 sd=0 m=1
.ends

* gf180-pll :: divider-ratio :: single div23_cell testbench (DR-001 Decision 3)
*
* Six independent copies of the SAME cell, so one transient covers every
* single-cell acceptance check at a given PVT point:
*
*   XA  P=0, 50% duty clock          -> divide by 2
*   XB  P=1, 50% duty clock          -> divide by 3   (MODIN tied high, i.e.
*                                       the chain-terminated last-cell case)
*   XC  P=0, 33% duty clock          -> divide by 2
*   XD  P=1, 67% duty clock          -> divide by 3
*   XE  P=1, clock at 1.5x kf        -> divide by 3   (speed margin)
*   XF  P=1, clock at 2.0x kf        -> divide by 3   (speed margin)
*
* XC / XD are the "both edges" check and they are not academic: a cell that is
* swallowing emits a 33%-duty CKOUT, and the 67% case is its complement, so
* every cell downstream of a swallowing cell is clocked by a duty-distorted
* waveform. Division must be exact for both, which is only true if the cell is
* purely rising-edge triggered.
*
* XE / XF quantify first-cell speed margin above the 200 MHz v1 ceiling
* (DR-002 Decision 2 budgets margin to the target, not the 400 MHz stretch);
* at kf = 200 MHz they are the 300 MHz and 400 MHz points.
*
* Running the same deck with a low kf is the "no minimum clock frequency"
* check that DR-001 Decision 3 requires of static CMOS -- it is the property
* dynamic/TSPC logic was rejected for, and it must hold at 125 C where
* leakage off a would-be dynamic node is worst.
*
* Expects from the generated header (sim/lib/simenv.sh):
*   .lib <process corner section>   one of typical/ff/ss/fs/sf
*   .temp <temp_c>
*   .param vsup=<supply volts>
*   .param kf=<input clock Hz>  ktstep=<max timestep>  ktstop=<transient stop>
*
* The div23_cell subcircuit is prepended to this file by the campaign runner
* (from design/netlist/div23_cell.spice, exported from design/div23_cell.sch),
* so the frozen netlist snapshot is deck + DUT in one file.

.param tvco='1/kf'
.param ttr='tvco/50'
.param ttd='tvco'
* 50% crossing of the first rising clock edge -- the phase reference used to
* extract clk->Q without depending on which edge index the output happens to
* land on.
.param tck0='ttd+ttr/2'

vdd vdd 0 dc 'vsup'
vhi hi 0 dc 'vsup'
vlo lo 0 dc 0

vck50 ck50 0 pulse(0 'vsup' 'ttd' 'ttr' 'ttr' 'tvco/2-ttr' 'tvco')
vck33 ck33 0 pulse(0 'vsup' 'ttd' 'ttr' 'ttr' 'tvco/3-ttr' 'tvco')
vck67 ck67 0 pulse(0 'vsup' 'ttd' 'ttr' 'ttr' '2*tvco/3-ttr' 'tvco')
vcke  cke  0 pulse(0 'vsup' 'ttd' 'ttr/1.5' 'ttr/1.5' 'tvco/3-ttr/1.5' 'tvco/1.5')
vckf  ckf  0 pulse(0 'vsup' 'ttd' 'ttr/2' 'ttr/2' 'tvco/4-ttr/2' 'tvco/2')

xa ck50 hi lo ckoa moa vdd 0 div23_cell
xb ck50 hi hi ckob mob vdd 0 div23_cell
xc ck33 hi lo ckoc moc vdd 0 div23_cell
xd ck67 hi hi ckod mdd vdd 0 div23_cell
xe cke  hi hi ckoe moe vdd 0 div23_cell
xf ckf  hi hi ckof mof vdd 0 div23_cell

.options reltol=1e-3 abstol=1e-10 vntol=1e-5 chgtol=1e-13
.tran {ktstep} {ktstop}

* --- division ratios: two output periods each, measured against the cell's
*     own input period (XE and XF run 1.5x and 2x faster than kf).
.meas tran ta1 when v(ckoa)='vsup/2' rise=1 td='ttd'
.meas tran ta3 when v(ckoa)='vsup/2' rise=3 td='ttd'
.meas tran na param='(ta3-ta1)/(2*tvco)'
.meas tran tb1 when v(ckob)='vsup/2' rise=1 td='ttd'
.meas tran tb3 when v(ckob)='vsup/2' rise=3 td='ttd'
.meas tran nb param='(tb3-tb1)/(2*tvco)'
.meas tran tc1 when v(ckoc)='vsup/2' rise=1 td='ttd'
.meas tran tc3 when v(ckoc)='vsup/2' rise=3 td='ttd'
.meas tran nc param='(tc3-tc1)/(2*tvco)'
.meas tran td1 when v(ckod)='vsup/2' rise=1 td='ttd'
.meas tran td3 when v(ckod)='vsup/2' rise=3 td='ttd'
.meas tran nd param='(td3-td1)/(2*tvco)'
.meas tran te1 when v(ckoe)='vsup/2' rise=1 td='ttd'
.meas tran te3 when v(ckoe)='vsup/2' rise=3 td='ttd'
.meas tran ne param='(te3-te1)/(2*tvco/1.5)'
.meas tran tf1 when v(ckof)='vsup/2' rise=1 td='ttd'
.meas tran tf3 when v(ckof)='vsup/2' rise=3 td='ttd'
.meas tran nf param='(tf3-tf1)/(2*tvco/2)'

* --- clk->Q of the cell, extracted modulo the input period so it does not
*     depend on which input edge produced output rise #1.
.meas tran tcq param='(ta1-tck0)-tvco*floor((ta1-tck0)/tvco)'

* --- output high times. The sign is corrected in the runner by adding one
*     output period when the DC operating point happens to start the cell high
*     (rise #3 and fall #3 are then one period apart in the other order).
.meas tran fa3 when v(ckoa)='vsup/2' fall=3 td='ttd'
.meas tran pwa param='fa3-ta3'
.meas tran fb3 when v(ckob)='vsup/2' fall=3 td='ttd'
.meas tran pwb param='fb3-tb3'

* --- MODOUT pulse width of the divide-by-3 cell: must be exactly one CKIN
*     period, because the previous (2x faster) cell has to see it as one of
*     ITS output periods.
.meas tran rmb2 when v(mob)='vsup/2' rise=2 td='ttd'
.meas tran fmb2 when v(mob)='vsup/2' fall=2 td='ttd'
.meas tran pwmb param='fmb2-rmb2'

* --- supply current (both moduli running, 6 cells) for a first-order power
*     figure; divided by 6 in the runner to give per-cell average.
.meas tran iavg avg i(vdd) from='ttd+2*tvco' to='ktstop'
