* Extracted by KLayout with GF180MCU LVS runset on : 11/09/2026 00:06

.SUBCKT vco_out_buffer CLK GND_VCO NB1 NB2 VDD_VCO Y5
M$1 VDD_VCO NB2 CLK VDD_VCO pfet_03v3 L=0.28U W=11.25U AS=5.625P AD=5.625P
+ PS=23.5U PD=23.5U
M$2 VDD_VCO NB1 NB2 VDD_VCO pfet_03v3 L=0.28U W=3.75U AS=1.875P AD=1.875P
+ PS=8.5U PD=8.5U
M$3 VDD_VCO Y5 NB1 VDD_VCO pfet_03v3 L=0.28U W=1.25U AS=0.625P AD=0.625P
+ PS=3.5U PD=3.5U
M$4 CLK NB2 GND_VCO GND_VCO nfet_03v3 L=0.28U W=4.5U AS=2.25P AD=2.25P PS=10U
+ PD=10U
M$5 NB2 NB1 GND_VCO GND_VCO nfet_03v3 L=0.28U W=1.5U AS=0.75P AD=0.75P PS=4U
+ PD=4U
M$6 NB1 Y5 GND_VCO GND_VCO nfet_03v3 L=0.28U W=0.5U AS=0.25P AD=0.25P PS=2U
+ PD=2U
.ENDS vco_out_buffer
