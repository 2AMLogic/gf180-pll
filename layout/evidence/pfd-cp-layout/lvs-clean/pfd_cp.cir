* Extracted by KLayout with GF180MCU LVS runset on : 21/09/2026 11:31

.SUBCKT pfd_cp IBP REF IBN VSS DN FB UP B0 ICN ICP VDD B1 VOUT
M$1 IBP IBP VDD VDD pfet_03v3 L=1U W=48U AS=24P AD=24P PS=97U PD=97U
M$2 ICP ICP VDD VDD pfet_03v3 L=1U W=12U AS=6P AD=6P PS=25U PD=25U
M$3 \$4 \$4 VDD VDD pfet_03v3 L=1U W=24U AS=12P AD=12P PS=49U PD=49U
M$4 \$5 \$4 VDD VDD pfet_03v3 L=1U W=24U AS=12P AD=12P PS=49U PD=49U
M$5 \$15 REF VDD VDD pfet_03v3 L=0.3U W=1.5U AS=1.5P AD=1.5P PS=5U PD=5U
M$6 \$16 \$15 VDD VDD pfet_03v3 L=0.3U W=1.5U AS=1.5P AD=1.5P PS=5U PD=5U
M$7 \$17 \$16 VDD VDD pfet_03v3 L=0.3U W=1.5U AS=1.5P AD=1.5P PS=5U PD=5U
M$8 \$18 \$17 VDD VDD pfet_03v3 L=0.3U W=1.5U AS=1.5P AD=1.5P PS=5U PD=5U
M$9 \$19 \$18 VDD VDD pfet_03v3 L=0.3U W=1.5U AS=1.5P AD=1.5P PS=5U PD=5U
M$10 \$20 REF VDD VDD pfet_03v3 L=0.3U W=1.5U AS=1.5P AD=1.5P PS=5U PD=5U
M$11 VDD \$19 \$20 VDD pfet_03v3 L=0.3U W=1.5U AS=1.5P AD=1.5P PS=5U PD=5U
M$12 \$22 \$20 VDD VDD pfet_03v3 L=0.3U W=1.5U AS=1.5P AD=1.5P PS=5U PD=5U
M$13 \$23 \$22 VDD VDD pfet_03v3 L=0.3U W=1.5U AS=1.5P AD=1.5P PS=5U PD=5U
M$14 UP \$23 VDD VDD pfet_03v3 L=0.3U W=1.5U AS=1.5P AD=1.5P PS=5U PD=5U
M$15 VDD \$74 UP VDD pfet_03v3 L=0.3U W=1.5U AS=1.5P AD=1.5P PS=5U PD=5U
M$16 \$74 \$75 VDD VDD pfet_03v3 L=0.3U W=1.5U AS=1.5P AD=1.5P PS=5U PD=5U
M$17 VDD UP \$74 VDD pfet_03v3 L=0.3U W=1.5U AS=1.5P AD=1.5P PS=5U PD=5U
M$18 \$26 UP VDD VDD pfet_03v3 L=0.3U W=1.5U AS=1.5P AD=1.5P PS=5U PD=5U
M$19 VDD DN \$26 VDD pfet_03v3 L=0.3U W=1.5U AS=1.5P AD=1.5P PS=5U PD=5U
M$20 \$77 DN VDD VDD pfet_03v3 L=0.3U W=1.5U AS=1.5P AD=1.5P PS=5U PD=5U
M$21 VDD \$75 \$77 VDD pfet_03v3 L=0.3U W=1.5U AS=1.5P AD=1.5P PS=5U PD=5U
M$22 DN \$77 VDD VDD pfet_03v3 L=0.3U W=1.5U AS=1.5P AD=1.5P PS=5U PD=5U
M$23 VDD \$78 DN VDD pfet_03v3 L=0.3U W=1.5U AS=1.5P AD=1.5P PS=5U PD=5U
M$24 VDD \$30 \$78 VDD pfet_03v3 L=0.3U W=1.5U AS=1.5P AD=1.5P PS=5U PD=5U
M$25 VDD \$31 \$30 VDD pfet_03v3 L=0.3U W=1.5U AS=1.5P AD=1.5P PS=5U PD=5U
M$26 \$31 \$79 VDD VDD pfet_03v3 L=0.3U W=1.5U AS=1.5P AD=1.5P PS=5U PD=5U
M$27 VDD FB \$31 VDD pfet_03v3 L=0.3U W=1.5U AS=1.5P AD=1.5P PS=5U PD=5U
M$28 VDD \$33 \$79 VDD pfet_03v3 L=0.3U W=1.5U AS=1.5P AD=1.5P PS=5U PD=5U
M$29 VDD \$34 \$33 VDD pfet_03v3 L=0.3U W=1.5U AS=1.5P AD=1.5P PS=5U PD=5U
M$30 VDD \$35 \$34 VDD pfet_03v3 L=0.3U W=1.5U AS=1.5P AD=1.5P PS=5U PD=5U
M$31 VDD \$36 \$35 VDD pfet_03v3 L=0.3U W=1.5U AS=1.5P AD=1.5P PS=5U PD=5U
M$32 VDD FB \$36 VDD pfet_03v3 L=0.3U W=1.5U AS=1.5P AD=1.5P PS=5U PD=5U
M$33 \$177 \$26 VDD VDD pfet_03v3 L=0.3U W=1.5U AS=1.5P AD=1.5P PS=5U PD=5U
M$34 \$178 \$177 VDD VDD pfet_03v3 L=0.3U W=1.5U AS=1.5P AD=1.5P PS=5U PD=5U
M$35 \$179 \$178 VDD VDD pfet_03v3 L=0.3U W=1.5U AS=1.5P AD=1.5P PS=5U PD=5U
M$36 \$180 \$179 VDD VDD pfet_03v3 L=0.3U W=1.5U AS=1.5P AD=1.5P PS=5U PD=5U
M$37 \$181 \$180 VDD VDD pfet_03v3 L=0.3U W=1.5U AS=1.5P AD=1.5P PS=5U PD=5U
M$38 \$182 \$181 VDD VDD pfet_03v3 L=0.3U W=1.5U AS=1.5P AD=1.5P PS=5U PD=5U
M$39 \$183 \$182 VDD VDD pfet_03v3 L=0.3U W=1.5U AS=1.5P AD=1.5P PS=5U PD=5U
M$40 \$184 \$183 VDD VDD pfet_03v3 L=0.3U W=1.5U AS=1.5P AD=1.5P PS=5U PD=5U
M$41 \$185 \$184 VDD VDD pfet_03v3 L=0.3U W=1.5U AS=1.5P AD=1.5P PS=5U PD=5U
M$42 \$186 \$185 VDD VDD pfet_03v3 L=0.3U W=1.5U AS=1.5P AD=1.5P PS=5U PD=5U
M$43 \$187 \$186 VDD VDD pfet_03v3 L=0.3U W=1.5U AS=1.5P AD=1.5P PS=5U PD=5U
M$44 \$188 \$187 VDD VDD pfet_03v3 L=0.3U W=1.5U AS=1.5P AD=1.5P PS=5U PD=5U
M$45 \$189 \$188 VDD VDD pfet_03v3 L=0.3U W=1.5U AS=1.5P AD=1.5P PS=5U PD=5U
M$46 \$190 \$189 VDD VDD pfet_03v3 L=0.3U W=1.5U AS=1.5P AD=1.5P PS=5U PD=5U
M$47 \$191 \$190 VDD VDD pfet_03v3 L=0.3U W=1.5U AS=1.5P AD=1.5P PS=5U PD=5U
M$48 \$192 \$191 VDD VDD pfet_03v3 L=0.3U W=1.5U AS=1.5P AD=1.5P PS=5U PD=5U
M$49 \$193 \$192 VDD VDD pfet_03v3 L=0.3U W=1.5U AS=1.5P AD=1.5P PS=5U PD=5U
M$50 \$194 \$193 VDD VDD pfet_03v3 L=0.3U W=1.5U AS=1.5P AD=1.5P PS=5U PD=5U
M$51 \$195 \$194 VDD VDD pfet_03v3 L=0.3U W=1.5U AS=1.5P AD=1.5P PS=5U PD=5U
M$52 \$196 \$195 VDD VDD pfet_03v3 L=0.3U W=1.5U AS=1.5P AD=1.5P PS=5U PD=5U
M$53 \$197 \$196 VDD VDD pfet_03v3 L=0.3U W=1.5U AS=1.5P AD=1.5P PS=5U PD=5U
M$54 \$198 \$197 VDD VDD pfet_03v3 L=0.3U W=1.5U AS=1.5P AD=1.5P PS=5U PD=5U
M$55 \$199 \$198 VDD VDD pfet_03v3 L=0.3U W=1.5U AS=1.5P AD=1.5P PS=5U PD=5U
M$56 \$200 \$199 VDD VDD pfet_03v3 L=0.3U W=1.5U AS=1.5P AD=1.5P PS=5U PD=5U
M$57 \$201 \$200 VDD VDD pfet_03v3 L=0.3U W=1.5U AS=1.5P AD=1.5P PS=5U PD=5U
M$58 \$75 \$201 VDD VDD pfet_03v3 L=0.3U W=1.5U AS=1.5P AD=1.5P PS=5U PD=5U
M$59 IBP \$92 \$88 VDD pfet_03v3 L=0.3U W=1U AS=0.5P AD=0.5P PS=3U PD=3U
M$60 \$88 B0 VDD VDD pfet_03v3 L=0.3U W=1U AS=0.5P AD=0.5P PS=3U PD=3U
M$61 \$97 \$88 VDD VDD pfet_03v3 L=1U W=12U AS=6P AD=6P PS=25U PD=25U
M$62 \$230 ICP \$97 VDD pfet_03v3 L=1U W=12U AS=6P AD=6P PS=25U PD=25U
M$63 IBP VSS \$160 VDD pfet_03v3 L=0.3U W=1U AS=0.5P AD=0.5P PS=3U PD=3U
M$64 \$160 VDD VDD VDD pfet_03v3 L=0.3U W=1U AS=0.5P AD=0.5P PS=3U PD=3U
M$65 \$230 ICP \$161 VDD pfet_03v3 L=1U W=12U AS=6P AD=6P PS=25U PD=25U
M$66 \$161 \$160 VDD VDD pfet_03v3 L=1U W=12U AS=6P AD=6P PS=25U PD=25U
M$67 \$89 B1 VDD VDD pfet_03v3 L=0.3U W=1U AS=0.5P AD=0.5P PS=3U PD=3U
M$68 IBP \$235 \$89 VDD pfet_03v3 L=0.3U W=1U AS=0.5P AD=0.5P PS=3U PD=3U
M$69 \$98 \$89 VDD VDD pfet_03v3 L=1U W=12U AS=6P AD=6P PS=25U PD=25U
M$70 \$230 ICP \$98 VDD pfet_03v3 L=1U W=12U AS=6P AD=6P PS=25U PD=25U
M$71 \$230 \$307 VOUT VDD pfet_03v3 L=0.3U W=6U AS=3P AD=3P PS=13U PD=13U
M$72 \$230 UP \$5 VDD pfet_03v3 L=0.3U W=6U AS=3P AD=3P PS=13U PD=13U
M$73 VOUT UP VOUT VDD pfet_03v3 L=0.3U W=3U AS=1.5P AD=1.5P PS=7U PD=7U
M$74 VDD B0 \$92 VDD pfet_03v3 L=0.3U W=1.5U AS=0.75P AD=0.75P PS=4U PD=4U
M$75 VDD B1 \$235 VDD pfet_03v3 L=0.3U W=1.5U AS=0.75P AD=0.75P PS=4U PD=4U
M$76 \$278 B1 VDD VDD pfet_03v3 L=0.3U W=1U AS=0.5P AD=0.5P PS=3U PD=3U
M$77 IBP \$235 \$278 VDD pfet_03v3 L=0.3U W=1U AS=0.5P AD=0.5P PS=3U PD=3U
M$78 \$230 ICP \$279 VDD pfet_03v3 L=1U W=12U AS=6P AD=6P PS=25U PD=25U
M$79 \$279 \$278 VDD VDD pfet_03v3 L=1U W=12U AS=6P AD=6P PS=25U PD=25U
M$80 VDD UP \$307 VDD pfet_03v3 L=0.3U W=1.5U AS=0.75P AD=0.75P PS=4U PD=4U
M$81 VDD DN \$306 VDD pfet_03v3 L=0.3U W=1.5U AS=0.75P AD=0.75P PS=4U PD=4U
M$82 \$266 IBP VDD VDD pfet_03v3 L=1U W=48U AS=24P AD=24P PS=98U PD=98U
M$84 \$267 VOUT \$266 \$266 pfet_03v3 L=1U W=48U AS=24P AD=24P PS=98U PD=98U
M$85 \$5 \$5 \$266 \$266 pfet_03v3 L=1U W=48U AS=24P AD=24P PS=98U PD=98U
M$88 \$3 IBN VSS VSS nfet_03v3 L=1U W=16U AS=8P AD=8P PS=33U PD=33U
M$89 \$4 VOUT \$3 VSS nfet_03v3 L=1U W=16U AS=8P AD=8P PS=33U PD=33U
M$90 \$5 \$5 \$3 VSS nfet_03v3 L=1U W=16U AS=8P AD=8P PS=33U PD=33U
M$91 \$21 REF \$20 VSS nfet_03v3 L=0.3U W=1U AS=1P AD=1P PS=4U PD=4U
M$92 VSS \$19 \$21 VSS nfet_03v3 L=0.3U W=1U AS=1P AD=1P PS=4U PD=4U
M$93 \$24 \$23 UP VSS nfet_03v3 L=0.3U W=1U AS=1P AD=1P PS=4U PD=4U
M$94 VSS \$74 \$24 VSS nfet_03v3 L=0.3U W=1U AS=1P AD=1P PS=4U PD=4U
M$95 \$25 \$75 \$74 VSS nfet_03v3 L=0.3U W=1U AS=1P AD=1P PS=4U PD=4U
M$96 VSS UP \$25 VSS nfet_03v3 L=0.3U W=1U AS=1P AD=1P PS=4U PD=4U
M$97 \$27 UP \$26 VSS nfet_03v3 L=0.3U W=1U AS=1P AD=1P PS=4U PD=4U
M$98 VSS DN \$27 VSS nfet_03v3 L=0.3U W=1U AS=1P AD=1P PS=4U PD=4U
M$99 \$28 DN VSS VSS nfet_03v3 L=0.3U W=1U AS=1P AD=1P PS=4U PD=4U
M$100 \$77 \$75 \$28 VSS nfet_03v3 L=0.3U W=1U AS=1P AD=1P PS=4U PD=4U
M$101 \$29 \$77 VSS VSS nfet_03v3 L=0.3U W=1U AS=1P AD=1P PS=4U PD=4U
M$102 DN \$78 \$29 VSS nfet_03v3 L=0.3U W=1U AS=1P AD=1P PS=4U PD=4U
M$103 \$32 \$79 VSS VSS nfet_03v3 L=0.3U W=1U AS=1P AD=1P PS=4U PD=4U
M$104 \$31 FB \$32 VSS nfet_03v3 L=0.3U W=1U AS=1P AD=1P PS=4U PD=4U
M$105 \$15 REF VSS VSS nfet_03v3 L=0.3U W=0.5U AS=0.5P AD=0.5P PS=3U PD=3U
M$106 \$16 \$15 VSS VSS nfet_03v3 L=0.3U W=0.5U AS=0.5P AD=0.5P PS=3U PD=3U
M$107 \$17 \$16 VSS VSS nfet_03v3 L=0.3U W=0.5U AS=0.5P AD=0.5P PS=3U PD=3U
M$108 \$18 \$17 VSS VSS nfet_03v3 L=0.3U W=0.5U AS=0.5P AD=0.5P PS=3U PD=3U
M$109 \$19 \$18 VSS VSS nfet_03v3 L=0.3U W=0.5U AS=0.5P AD=0.5P PS=3U PD=3U
M$110 \$22 \$20 VSS VSS nfet_03v3 L=0.3U W=0.5U AS=0.5P AD=0.5P PS=3U PD=3U
M$111 \$23 \$22 VSS VSS nfet_03v3 L=0.3U W=0.5U AS=0.5P AD=0.5P PS=3U PD=3U
M$112 VSS \$30 \$78 VSS nfet_03v3 L=0.3U W=0.5U AS=0.5P AD=0.5P PS=3U PD=3U
M$113 VSS \$31 \$30 VSS nfet_03v3 L=0.3U W=0.5U AS=0.5P AD=0.5P PS=3U PD=3U
M$114 VSS \$33 \$79 VSS nfet_03v3 L=0.3U W=0.5U AS=0.5P AD=0.5P PS=3U PD=3U
M$115 VSS \$34 \$33 VSS nfet_03v3 L=0.3U W=0.5U AS=0.5P AD=0.5P PS=3U PD=3U
M$116 VSS \$35 \$34 VSS nfet_03v3 L=0.3U W=0.5U AS=0.5P AD=0.5P PS=3U PD=3U
M$117 VSS \$36 \$35 VSS nfet_03v3 L=0.3U W=0.5U AS=0.5P AD=0.5P PS=3U PD=3U
M$118 VSS FB \$36 VSS nfet_03v3 L=0.3U W=0.5U AS=0.5P AD=0.5P PS=3U PD=3U
M$119 IBN IBN VSS VSS nfet_03v3 L=1U W=16U AS=8P AD=8P PS=33U PD=33U
M$120 ICN ICN VSS VSS nfet_03v3 L=1U W=4U AS=2P AD=2P PS=9U PD=9U
M$121 \$177 \$26 VSS VSS nfet_03v3 L=0.3U W=0.5U AS=0.5P AD=0.5P PS=3U PD=3U
M$122 \$178 \$177 VSS VSS nfet_03v3 L=0.3U W=0.5U AS=0.5P AD=0.5P PS=3U PD=3U
M$123 \$179 \$178 VSS VSS nfet_03v3 L=0.3U W=0.5U AS=0.5P AD=0.5P PS=3U PD=3U
M$124 \$180 \$179 VSS VSS nfet_03v3 L=0.3U W=0.5U AS=0.5P AD=0.5P PS=3U PD=3U
M$125 \$181 \$180 VSS VSS nfet_03v3 L=0.3U W=0.5U AS=0.5P AD=0.5P PS=3U PD=3U
M$126 \$182 \$181 VSS VSS nfet_03v3 L=0.3U W=0.5U AS=0.5P AD=0.5P PS=3U PD=3U
M$127 \$183 \$182 VSS VSS nfet_03v3 L=0.3U W=0.5U AS=0.5P AD=0.5P PS=3U PD=3U
M$128 \$184 \$183 VSS VSS nfet_03v3 L=0.3U W=0.5U AS=0.5P AD=0.5P PS=3U PD=3U
M$129 \$185 \$184 VSS VSS nfet_03v3 L=0.3U W=0.5U AS=0.5P AD=0.5P PS=3U PD=3U
M$130 \$186 \$185 VSS VSS nfet_03v3 L=0.3U W=0.5U AS=0.5P AD=0.5P PS=3U PD=3U
M$131 \$187 \$186 VSS VSS nfet_03v3 L=0.3U W=0.5U AS=0.5P AD=0.5P PS=3U PD=3U
M$132 \$188 \$187 VSS VSS nfet_03v3 L=0.3U W=0.5U AS=0.5P AD=0.5P PS=3U PD=3U
M$133 \$189 \$188 VSS VSS nfet_03v3 L=0.3U W=0.5U AS=0.5P AD=0.5P PS=3U PD=3U
M$134 \$190 \$189 VSS VSS nfet_03v3 L=0.3U W=0.5U AS=0.5P AD=0.5P PS=3U PD=3U
M$135 \$191 \$190 VSS VSS nfet_03v3 L=0.3U W=0.5U AS=0.5P AD=0.5P PS=3U PD=3U
M$136 \$192 \$191 VSS VSS nfet_03v3 L=0.3U W=0.5U AS=0.5P AD=0.5P PS=3U PD=3U
M$137 \$193 \$192 VSS VSS nfet_03v3 L=0.3U W=0.5U AS=0.5P AD=0.5P PS=3U PD=3U
M$138 \$194 \$193 VSS VSS nfet_03v3 L=0.3U W=0.5U AS=0.5P AD=0.5P PS=3U PD=3U
M$139 \$195 \$194 VSS VSS nfet_03v3 L=0.3U W=0.5U AS=0.5P AD=0.5P PS=3U PD=3U
M$140 \$196 \$195 VSS VSS nfet_03v3 L=0.3U W=0.5U AS=0.5P AD=0.5P PS=3U PD=3U
M$141 \$197 \$196 VSS VSS nfet_03v3 L=0.3U W=0.5U AS=0.5P AD=0.5P PS=3U PD=3U
M$142 \$198 \$197 VSS VSS nfet_03v3 L=0.3U W=0.5U AS=0.5P AD=0.5P PS=3U PD=3U
M$143 \$199 \$198 VSS VSS nfet_03v3 L=0.3U W=0.5U AS=0.5P AD=0.5P PS=3U PD=3U
M$144 \$200 \$199 VSS VSS nfet_03v3 L=0.3U W=0.5U AS=0.5P AD=0.5P PS=3U PD=3U
M$145 \$201 \$200 VSS VSS nfet_03v3 L=0.3U W=0.5U AS=0.5P AD=0.5P PS=3U PD=3U
M$146 \$75 \$201 VSS VSS nfet_03v3 L=0.3U W=0.5U AS=0.5P AD=0.5P PS=3U PD=3U
M$147 IBN B0 \$93 VSS nfet_03v3 L=0.3U W=1U AS=0.5P AD=0.5P PS=3U PD=3U
M$148 \$93 \$92 VSS VSS nfet_03v3 L=0.3U W=1U AS=0.5P AD=0.5P PS=3U PD=3U
M$149 \$94 \$93 VSS VSS nfet_03v3 L=1U W=4U AS=2P AD=2P PS=9U PD=9U
M$150 \$157 ICN \$94 VSS nfet_03v3 L=1U W=4U AS=2P AD=2P PS=9U PD=9U
M$151 IBN VDD \$158 VSS nfet_03v3 L=0.3U W=1U AS=0.5P AD=0.5P PS=3U PD=3U
M$152 \$158 VSS VSS VSS nfet_03v3 L=0.3U W=1U AS=0.5P AD=0.5P PS=3U PD=3U
M$153 \$159 \$158 VSS VSS nfet_03v3 L=1U W=4U AS=2P AD=2P PS=9U PD=9U
M$154 \$95 \$235 VSS VSS nfet_03v3 L=0.3U W=1U AS=0.5P AD=0.5P PS=3U PD=3U
M$155 IBN B1 \$95 VSS nfet_03v3 L=0.3U W=1U AS=0.5P AD=0.5P PS=3U PD=3U
M$156 \$96 \$95 VSS VSS nfet_03v3 L=1U W=4U AS=2P AD=2P PS=9U PD=9U
M$157 \$157 ICN \$96 VSS nfet_03v3 L=1U W=4U AS=2P AD=2P PS=9U PD=9U
M$158 VOUT DN \$157 VSS nfet_03v3 L=0.3U W=6U AS=3P AD=3P PS=13U PD=13U
M$159 \$5 \$306 \$157 VSS nfet_03v3 L=0.3U W=6U AS=3P AD=3P PS=13U PD=13U
M$160 IBN B1 \$264 VSS nfet_03v3 L=0.3U W=1U AS=0.5P AD=0.5P PS=3U PD=3U
M$161 \$264 \$235 VSS VSS nfet_03v3 L=0.3U W=1U AS=0.5P AD=0.5P PS=3U PD=3U
M$162 \$157 ICN \$265 VSS nfet_03v3 L=1U W=4U AS=2P AD=2P PS=9U PD=9U
M$163 \$265 \$264 VSS VSS nfet_03v3 L=1U W=4U AS=2P AD=2P PS=9U PD=9U
M$164 \$157 ICN \$159 VSS nfet_03v3 L=1U W=4U AS=2P AD=2P PS=9U PD=9U
M$165 VOUT \$306 VOUT VSS nfet_03v3 L=0.3U W=3U AS=1.5P AD=1.5P PS=7U PD=7U
M$166 \$92 B0 VSS VSS nfet_03v3 L=0.3U W=0.5U AS=0.25P AD=0.25P PS=2U PD=2U
M$167 \$235 B1 VSS VSS nfet_03v3 L=0.3U W=0.5U AS=0.25P AD=0.25P PS=2U PD=2U
M$168 \$307 UP VSS VSS nfet_03v3 L=0.3U W=0.5U AS=0.25P AD=0.25P PS=2U PD=2U
M$169 \$306 DN VSS VSS nfet_03v3 L=0.3U W=0.5U AS=0.25P AD=0.25P PS=2U PD=2U
M$170 \$267 \$267 VSS VSS nfet_03v3 L=1U W=16U AS=8P AD=8P PS=33U PD=33U
M$171 \$5 \$267 VSS VSS nfet_03v3 L=1U W=16U AS=8P AD=8P PS=33U PD=33U
.ENDS pfd_cp
