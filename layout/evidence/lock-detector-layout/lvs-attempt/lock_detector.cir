* Extracted by KLayout with GF180MCU LVS runset on : 21/09/2026 10:57

.SUBCKT lock_detector VSS
M$1 \$102 \$90 \$28 \$73 pfet_03v3 L=0.28U W=2.5U AS=2.5P AD=2.5P PS=7U PD=7U
M$2 \$28 \$89 \$73 \$73 pfet_03v3 L=0.28U W=2.5U AS=2.5P AD=2.5P PS=7U PD=7U
M$3 \$101 \$87 \$73 \$73 pfet_03v3 L=0.28U W=2.5U AS=2.5P AD=2.5P PS=7U PD=7U
M$4 \$73 \$86 \$73 \$73 pfet_03v3 L=0.28U W=2.5U AS=2.5P AD=2.5P PS=7U PD=7U
M$5 \$73 \$76 \$73 \$73 pfet_03v3 L=0.28U W=2.5U AS=2.5P AD=2.5P PS=7U PD=7U
M$6 \$98 \$83 \$73 \$73 pfet_03v3 L=0.28U W=2.5U AS=2.5P AD=2.5P PS=7U PD=7U
M$7 \$95 \$75 \$73 \$73 pfet_03v3 L=0.28U W=2.5U AS=2.5P AD=2.5P PS=7U PD=7U
M$8 \$94 \$72 \$73 \$73 pfet_03v3 L=0.28U W=2.5U AS=2.5P AD=2.5P PS=7U PD=7U
M$9 \$100 \$85 \$73 \$73 pfet_03v3 L=0.28U W=2.5U AS=2.5P AD=2.5P PS=7U PD=7U
M$10 \$96 \$77 \$73 \$73 pfet_03v3 L=0.28U W=2.5U AS=2.5P AD=2.5P PS=7U PD=7U
M$11 \$73 \$74 \$73 \$73 pfet_03v3 L=0.28U W=2.5U AS=2.5P AD=2.5P PS=7U PD=7U
M$12 \$106 \$82 \$73 \$73 pfet_03v3 L=0.28U W=2.5U AS=2.5P AD=2.5P PS=7U PD=7U
M$13 \$28 \$103 \$73 \$73 pfet_03v3 L=0.28U W=1.2U AS=1.2P AD=1.2P PS=4.4U
+ PD=4.4U
M$14 \$104 \$92 \$73 \$73 pfet_03v3 L=0.28U W=2.5U AS=2.5P AD=2.5P PS=7U PD=7U
M$15 \$18 \$73 \$73 \$73 pfet_03v3 L=20U W=0.22U AS=0.43P AD=0.43P PS=3U PD=3U
M$16 \$97 \$79 \$73 \$73 pfet_03v3 L=0.28U W=2.5U AS=2.5P AD=2.5P PS=7U PD=7U
M$17 \$105 \$81 \$73 \$73 pfet_03v3 L=0.28U W=2.5U AS=2.5P AD=2.5P PS=7U PD=7U
M$18 \$73 \$78 \$73 \$73 pfet_03v3 L=0.28U W=2.5U AS=2.5P AD=2.5P PS=7U PD=7U
M$19 \$73 \$80 \$73 \$73 pfet_03v3 L=0.28U W=2.5U AS=2.5P AD=2.5P PS=7U PD=7U
M$20 \$99 \$84 \$73 \$73 pfet_03v3 L=0.28U W=2.5U AS=2.5P AD=2.5P PS=7U PD=7U
M$21 \$73 \$18 \$73 VSS nfet_03v3 L=6U W=30U AS=30P AD=30P PS=62U PD=62U
M$22 \$73 \$134 \$133 VSS nfet_03v3 L=2U W=8U AS=8P AD=8P PS=18U PD=18U
M$23 \$73 \$132 \$131 VSS nfet_03v3 L=2U W=8U AS=8P AD=8P PS=18U PD=18U
M$24 \$73 \$130 \$129 VSS nfet_03v3 L=2U W=8U AS=8P AD=8P PS=18U PD=18U
M$25 \$73 \$128 \$127 VSS nfet_03v3 L=2U W=8U AS=8P AD=8P PS=18U PD=18U
M$26 \$18 \$88 \$73 VSS nfet_03v3 L=0.5U W=2U AS=2P AD=2P PS=6U PD=6U
M$27 \$17 \$43 \$73 VSS nfet_03v3 L=0.28U W=2U AS=2P AD=2P PS=6U PD=6U
M$28 \$73 \$38 \$73 VSS nfet_03v3 L=0.28U W=2U AS=2P AD=2P PS=6U PD=6U
M$29 \$73 \$36 \$73 VSS nfet_03v3 L=0.28U W=2U AS=2P AD=2P PS=6U PD=6U
M$30 \$28 \$46 \$73 VSS nfet_03v3 L=0.28U W=1U AS=1P AD=1P PS=4U PD=4U
M$31 \$16 \$37 \$73 VSS nfet_03v3 L=0.28U W=2U AS=2P AD=2P PS=6U PD=6U
M$32 \$73 \$44 \$73 VSS nfet_03v3 L=0.28U W=2U AS=2P AD=2P PS=6U PD=6U
M$33 \$24 \$41 \$23 VSS nfet_03v3 L=0.28U W=1U AS=1P AD=1P PS=4U PD=4U
M$34 \$26 \$42 \$25 VSS nfet_03v3 L=0.28U W=1U AS=1P AD=1P PS=4U PD=4U
M$35 \$27 \$45 \$73 VSS nfet_03v3 L=0.28U W=1U AS=1P AD=1P PS=4U PD=4U
M$36 \$29 \$47 \$28 VSS nfet_03v3 L=0.28U W=1U AS=1P AD=1P PS=4U PD=4U
M$37 \$30 \$49 \$73 VSS nfet_03v3 L=0.28U W=1U AS=1P AD=1P PS=4U PD=4U
M$38 \$20 \$39 \$19 VSS nfet_03v3 L=0.28U W=1U AS=1P AD=1P PS=4U PD=4U
M$39 \$13 \$31 \$73 VSS nfet_03v3 L=0.28U W=2U AS=2P AD=2P PS=6U PD=6U
M$40 \$22 \$40 \$21 VSS nfet_03v3 L=0.28U W=1U AS=1P AD=1P PS=4U PD=4U
M$41 \$28 \$48 \$73 VSS nfet_03v3 L=0.28U W=0.5U AS=0.5P AD=0.5P PS=3U PD=3U
M$42 \$15 \$35 \$73 VSS nfet_03v3 L=0.28U W=2U AS=2P AD=2P PS=6U PD=6U
M$43 \$73 \$32 \$73 VSS nfet_03v3 L=0.28U W=2U AS=2P AD=2P PS=6U PD=6U
M$44 \$14 \$33 \$73 VSS nfet_03v3 L=0.28U W=2U AS=2P AD=2P PS=6U PD=6U
M$45 \$73 \$34 \$73 VSS nfet_03v3 L=0.28U W=2U AS=2P AD=2P PS=6U PD=6U
.ENDS lock_detector
