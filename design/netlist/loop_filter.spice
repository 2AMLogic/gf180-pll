* gf180-pll :: loop_filter -- generated by design/netlist.sh from loop_filter.sch
* xschem XSCHEM V3.4.7; do not edit by hand.
** sch_path: design/loop_filter.sch
.subckt loop_filter VCTRL VSS
*.iopin VCTRL
*.iopin VSS
XRF1 NR1 VCTRL VSS ppolyf_u r_width=2u r_length=107u m=1
XRF2 NR2 NR1 VSS ppolyf_u r_width=2u r_length=107u m=1
XRF3 NR3 NR2 VSS ppolyf_u r_width=2u r_length=107u m=1
XRF4 NZ NR3 VSS ppolyf_u r_width=2u r_length=107u m=1
XCF1 NZ VSS cap_nmos_03v3_b c_width=87u c_length=87u m=1
XCF2 NZ VSS cap_nmos_03v3_b c_width=87u c_length=87u m=1
XCF3 NZ VSS cap_nmos_03v3_b c_width=87u c_length=87u m=1
XCF4 NZ VSS cap_nmos_03v3_b c_width=87u c_length=87u m=1
XCF5 VCTRL VSS cap_mim_2f0_m2m3_noshield c_width=31.4u c_length=31.4u m=1
.ends
