* gf180-pll :: reference-spur-band-top :: closed-loop reference spur MEASURED
* at the 200 MHz top of the ratified output band (#510)
*
* WHY THIS DECK EXISTS SEPARATELY FROM sim/reference-spur's.  That campaign
* measures the same physical quantity -- the +/- f_ref sidebands around the
* carrier of the locked output -- at f_out = 150 MHz, band 6, N = 6, and its
* one record is at that single output frequency.  The spur scales with output
* frequency (theta = 2*pi*f_out*TIE), so spec/pll.md's <= -55 dBc line binds
* at the 200 MHz ceiling of the ratified output band, not at 150 MHz, and
* spec/pll.md's own derivation is stated there.  The committed record
* therefore reports a SCALED column, spur_dbc_at_200mhz = spur_dbc + 2.50 dB,
* labelled as arithmetic rather than measurement -- and at two corners
* (ff/-40 C/3.63 V and sf/-40 C/2.97 V) that arithmetic lands 0.1-0.5 dB on
* the wrong side of the line.  Nothing in this repository has measured the
* spur AT 200 MHz.  This deck is that measurement.
*
* A separate campaign rather than a second grid inside sim/reference-spur
* because the manifest-level `checks` -- `fout` inside its band, `nmeas` at
* the configured N -- are per-manifest, not per-point
* (sim/harness/README.md), and this operating point has a different N and a
* different output band.  Same reason sim/period-jitter-band-top is a sibling
* of sim/period-jitter rather than a second grid inside it.
*
* WHAT CHANGES FROM sim/reference-spur, AND WHAT DELIBERATELY DOES NOT.
* Changed, and only these:
*   f_out   150 MHz -> 200 MHz  (the whole point of this campaign)
*   N       6 -> 8              (f_ref is held, so N carries the change)
*   band    6 everywhere -> per corner, 6 at 34 points / 7 at 11
* Held identical, so the difference this campaign measures is attributable to
* the output frequency and nothing else:
*   f_ref            25 MHz -- the same reference rate, so the once-per-
*                              reference-cycle charge event that MAKES the
*                              spur is excited at the same rate; only the ring
*                              it modulates has changed
*   Icp trim code    0 (one unit leg) -- not a convenience: it is what
*                              spec/pll.md's Icp trim-code rule REQUIRES at
*                              f_ref = 25 MHz.  Holding f_ref is what lets
*                              this campaign hold the trim code too
*   bias sources     ideal, 4x unit-leg, as every closed-loop campaign here
*   timing           the same .tran controls, the same spectral windows
*                              (wa/wb/wcyc) and the same lock baseline; at
*                              200 MHz each 16-reference-period window is 128
*                              output cycles instead of 96
*   reduction        sim/reference-spur/testbench/derive.py itself, loaded and
*                              not copied (see derive.py in this directory)
*
* THE BAND CODE IS NOT A FREE CHOICE.  `spec/pll.md#band-selection-rule`
* (normative, DR-003 Decision 4) requires the LOWEST 3-bit code that reaches
* the target frequency.  Applied to sim/vco-tuning-range's committed f(Vctrl)
* record at 200 MHz that is band 6 at 34 of the 45 PVT points and band 7 at
* the other 11 -- the cold and/or high-supply points where band 6 tops out
* below 200 MHz.  So `b0_code`/`b1_code`/`b2_code` arrive here from the
* manifest's `op` sweep axis, per point, not from a fixed `params` entry;
* band_and_vstart_from_vco_record.py in this directory derives all 45 from the
* committed record and the ratified rule and re-checks the manifest against
* them.  Configuring one convenient static band across the whole grid would be
* measuring a mis-configured part at some corners, and spec/pll.md says no row
* of the specification applies to such a part.  This is also why 200 MHz could
* not simply be dialled into sim/reference-spur's existing manifest.
*
* DEVICE MISMATCH IS OFF IN THIS DECK, exactly as it is in sim/reference-spur.
* What it measures is the SYSTEMATIC, corner-driven spur; the statistical
* charge-pump mismatch contribution is sim/mc-cp-mismatch's (#15), and
* spec/pll.md's derivation (DR-018) adds the two.  A number from this deck is
* therefore comparable with the measured 150 MHz record and with the
* systematic rows of that derivation, and is NOT comparable with its
* -56.6 dBc worst-case stack, which is systematic + statistical.  See
* tb.json's Methodology, which states the relation in full.
*
* DUT: `pll_top` -- design/pll_top.sch, netlisted by design/netlist.sh into
* design/netlist/pll_top.spice, composed ahead of this fragment by tb.json's
* `dut` key (sim/harness/testbench.py).  Nothing here is a hand-transcribed
* copy of the design (#52).  The 36-port instance line and every fixed
* configuration-bit code below are GENERATED by sim/lib/pll_top_dut.sh
* (`cloop_instance`, `cloop_divider_params`, `cloop_trim_params`,
* `cloop_window_trim_params`) and re-checked against it by check_config.sh in
* this directory, which additionally checks the PER-POINT band bits against
* `cloop_band_params` for the band each point id names.
*
* Expects from the harness-generated header:
*   vdd_val   supply for this PVT point        vdd_nom  nominal supply
*   temp_c    temperature for this PVT point
* and from tb.json's `params` / `sweeps`:
*   fref      reference frequency, Hz
*   nratio    the divide ratio the SEL/P bits below encode (8 here)
*   b*_code   VCO band-select bits            (per point, from the `op` axis)
*   cpb*_code charge-pump Icp trim bits       (sim/lib/pll_top_dut.sh)
*   sel*_code, p*_code  divider chain-length / modulus bits   (   "   )
*   vstart    control-node voltage the loop is released from (per point)
*   ta, tb    the two late instants the lock criterion is evaluated at
*   wa, wb, wcyc   the spectral window list (start, end, reference periods)
*   ktstep, ktstop, ktstart, ktmax   transient controls (see tb.json)

*--------------------------------------------------------------- stimulus ---
* Charge-pump bias references.  Four ideal sources at 4x the unit-leg current,
* exactly as sim/devchar-cp, sim/pfd-deadzone, sim/cp-compliance,
* sim/reference-spur and sim/pll-top-smoke drive them: the bias generator is a
* separate, not-yet-designed block (design/README.md, "Bias generation is out
* of scope for this block"), so driving these ideally keeps the measured
* behaviour the LOOP's own rather than folding in a reference whose mismatch
* has no design behind it yet.
.param iunit=8u

* Reference clock.  200 ps edges rather than an ideal step, for the same
* reason sim/pfd-deadzone and sim/pll-top-smoke use them: a zero-rise-time
* stimulus flatters every delay in the PFD's set path, and the PFD set path is
* precisely what this campaign's timestep ceiling is sized from.
*
* The reference is IDEAL -- no jitter, no duty-cycle error.  That is the
* condition spec/pll.md's Reference spur row is written against ("Reference:
* ideal"), and it is also a LIMITATION of any record this deck mints: a spur
* contribution driven by reference jitter is out of scope here by
* construction, and the reference input's own electrical contract is
* sim/reference-input-contract's (#499, DR-019).
.param tref='1/fref'
.param tstart='0.5*tref'

vvdd     vdd     0 dc 'vdd_val'
vvddvco  vdd_vco 0 dc 'vdd_val'
vvdddiv  vdd_div 0 dc 'vdd_val'
vgndvco  gnd_vco 0 dc 0
vvss     vss     0 dc 0

vref ref 0 pulse(0 'vdd_val' 'tstart' 200p 200p '0.5*tref' 'tref')

* Static configuration.  Every one of these is a real pin on the block: DR-001
* Decision 2 keeps band select a static input with no calibration FSM, and
* DR-001 Decision 3 does the same for N.  The band bits are per point (see
* above); everything else is fixed by tb.json's `params`.  All of them are
* checked by check_config.sh.
vb0   b0   0 dc 'vdd_val*b0_code'
vb1   b1   0 dc 'vdd_val*b1_code'
vb2   b2   0 dc 'vdd_val*b2_code'
vcpb0 cpb0 0 dc 'vdd_val*cpb0_code'
vcpb1 cpb1 0 dc 'vdd_val*cpb1_code'

* Lock-detector window trim (DR-014, #411): a 4-bit STATIC process trim,
* set once at test and held for the life of the part, so it is a DC source
* like the band and Icp codes beside it and never changes inside a run.
* The code this deck runs at comes from the campaign's own runner/manifest
* (sim/lib/pll_top_dut.sh's cloop_window_trim_params), not from here.
vldt0 ldt0 0 dc 'vdd_val*ldt0_code'
vldt1 ldt1 0 dc 'vdd_val*ldt1_code'
vldt2 ldt2 0 dc 'vdd_val*ldt2_code'
vldt3 ldt3 0 dc 'vdd_val*ldt3_code'

vp0   p0   0 dc 'vdd_val*p0_code'
vp1   p1   0 dc 'vdd_val*p1_code'
vp2   p2   0 dc 'vdd_val*p2_code'
vp3   p3   0 dc 'vdd_val*p3_code'
vp4   p4   0 dc 'vdd_val*p4_code'
vp5   p5   0 dc 'vdd_val*p5_code'
vs0   sel0 0 dc 'vdd_val*sel0_code'
vs1   sel1 0 dc 'vdd_val*sel1_code'
vs2   sel2 0 dc 'vdd_val*sel2_code'
vs3   sel3 0 dc 'vdd_val*sel3_code'
vs4   sel4 0 dc 'vdd_val*sel4_code'
vs5   sel5 0 dc 'vdd_val*sel5_code'

iibn vdd ibn dc 'iunit'
iicn vdd icn dc 'iunit'
iibp ibp 0   dc 'iunit'
iicp icp 0   dc 'iunit'

* The DUT.  This instance line is `cloop_instance`'s output verbatim, so the
* 36-port order is never transcribed by hand.
xdut ref b0 b1 b2 cpb0 cpb1 ldt0 ldt1 ldt2 ldt3 p0 p1 p2 p3 p4 p5 sel0 sel1 sel2 sel3 sel4 sel5
+ ibn icn ibp icp clk divout fb lock vctrl vdd vdd_vco gnd_vco vdd_div vss
+ pll_top

*--------------------------------------------------------- initial state ---
* The control node is RELEASED at `vstart`, which for THIS campaign is the
* per-corner estimate of the lock point read out of sim/vco-tuning-range's
* committed f(Vctrl) table (record 20260804-162735-72883fb,
* corners/.../raw_measures.csv) at 200 MHz, IN THE BAND THE BAND-SELECTION
* RULE SELECTS FOR THAT CORNER -- band 6 at 34 points, band 7 at 11 -- by
* linear interpolation between that record's seven control points.  That is
* deliberate and it is NOT the cold-start release sim/pll-top-smoke and
* sim/lock-time use:
*
*   - This campaign measures a STEADY-STATE spectral property.  Lock TIME from
*     a cold start is #12's campaign (sim/lock-time) and nothing here may be
*     read as one -- the release point is chosen to get to steady state for
*     the least wall clock, which is exactly what would make a lock-time
*     number from this deck meaningless.
*   - The loop's slow closed-loop pole sits at 1/(R*C1) = 9.3 us regardless of
*     how much Icp is applied (spec/pll.md's ~43 us STRUCTURAL settling floor,
*     DR-006 Decision 7), so the residual control-voltage error decays by one
*     e-fold per 9.3 us no matter where it starts.  Starting ~0.1 V away
*     rather than ~0.7 V away removes the frequency-acquisition slew (the
*     control node slews at only Icp/C1 = 14 mV/us at this trim code) and
*     leaves the exponential tail, which is what actually has to finish.
*   - The residual is not assumed away: derive.py fits the control-node slope
*     in every spectral window and converts it into the per-reference-cycle
*     charge it represents (`drift_q_fc`), to be read against the charge-pump
*     asymmetry the spur is made of.  A point whose drift charge is a large
*     fraction of the asymmetry charge is reporting an upper bound, and the
*     record says so.
.ic v(vctrl)='vstart'

* Break the ring's DC symmetry so the operating point is not the metastable
* all-nodes-at-mid solution.  Same constraint sim/vco-tuning-range applies and
* the same release sim/pll-top-smoke uses.  `uic` is deliberately NOT used:
* the VCO's constant-gm bias generator must be solved to its operating point
* before t=0, or the first microseconds would be a bias start-up transient
* masquerading as loop settling.
.ic v(xdut.xvco.y1)=0 v(xdut.xvco.y2)='vdd_val' v(xdut.xvco.y3)=0
+ v(xdut.xvco.y4)='vdd_val' v(xdut.xvco.y5)=0

*-------------------------------------------------------------- lock criterion
* Same criterion sim/pll-top-smoke uses, retargeted to N = 8, and for the same
* reason: a spectral number taken from a loop that is not actually locked is
* not a spur.
*
*   (a) FREQUENCY.  In a type-II loop a residual frequency error shows up as a
*       REF->FB delay that slips linearly at exactly (df/f) seconds per
*       second, so differencing that delay at two instants gives the residual
*       fractional frequency error directly, to picosecond resolution.
*   (b) PHASE.  That static phase error is itself small against a reference
*       period.
*
* ta and tb are placed by tb.json on a reference HALF-period (tstart +
* (k+0.5)*tref), so "the first REF rise after t" and "the first FB rise after
* t" are normally the same cycle's pair.  Both are inside the stored window
* (see ktstart).
*
* That placement is NOT on its own alias-proof (#273).  A trig/targ delay is
* wrapped into one reference period by construction, so when the static phase
* error straddles zero a sample can still latch the NEXT FB edge and read
* ~tref instead of ~0 -- which is what sim/period-jitter record
* 20260906-063728-f3c9c23 hit, on a deck with the same half-period placement.
* tb.json's `dphi` therefore unwraps the difference into (-tref/2, +tref/2]
* before `ferr` differentiates it, and `ferr_fb` (= ffb/fref - 1, a period
* count, no wrap at all) closes the aliasing blind spot that unwrapping leaves
* at multiples of tref/(tb-ta).
*
* The `.measure` cards themselves live in tb.json's `raw_measures` -- the
* harness owns them (a fragment may not carry `.meas`), which is why this
* block is a comment here and a manifest entry there.

*------------------------------------------------------------------ analysis
* rshunt: the charge pump's disabled trim legs leave their cascode mid-node
* driven only by two off devices -- a floating node for the DC operating
* point.  Same 1 Tohm shunt sim/pfd-deadzone and sim/pll-top-smoke use; at
* 3.3 V it is 3.3 pA against a multi-microamp signal.
* itl4: transient Newton-iteration limit, a solver-EFFORT knob.  Every
* convergence TOLERANCE is left at the value sim/reference-spur uses, so a
* 200 MHz number from this deck is comparable with that campaign's 150 MHz
* one -- which is the whole point of running it.
*
* These are in tb.json's `options`, not here, for the same reason as the
* `.measure` cards: the harness owns the generated deck's directives.
