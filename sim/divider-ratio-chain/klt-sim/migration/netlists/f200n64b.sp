* gf180-pll :: divider-ratio-chain :: klt sim circuit body, f200n64 slice
*
* Generated by generate.py from testbench/tb.json -- same composition as the
* #1083 pilot body netlist-f200n33.sp: the committed DUT
* design/netlist/divider_chain.spice composed with the campaign stimulus
* testbench/tb_divider_chain.sp, this sweep point's parameters, and the
* campaign's four solver options. vdd_val stays the supply axis (corners.params
* on the request); the .measure cards that consume these params live in the
* request, not here.
* ---- f200n64 sweep-point parameters (tb.json sweeps.point.points.f200n64)
.param kf=200e6
.param ktstep=5e-11
.param ktstop=1.06e-06
.param kn=64
.param ksel0=0
.param ksel1=0
.param ksel2=0
.param ksel3=0
.param ksel4=0
.param ksel5=1
.param kp0=0
.param kp1=0
.param kp2=0
.param kp3=0
.param kp4=0
.param kp5=0
.param tsetup_s=5e-11
.param thold_s=1e-10
* ---- PVT parameter (altered per corner by the request's corners.params)
.param vdd_val=3.3
* ---- solver options (tb.json options, verbatim)
.options reltol=1e-3
.options abstol=1e-10
.options vntol=1e-5
.options chgtol=1e-13
* ---- DUT (composed by netlist.sh from design/divider_chain.sch)
.include ../../../../../design/netlist/divider_chain.spice
* ---- testbench stimulus (sim/divider-ratio-chain/testbench)
.include ../../../testbench/tb_divider_chain.sp
