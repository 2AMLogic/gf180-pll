* Reference schematic for divider_chain (issue #310).
*
* Flattened re-expression of design/netlist/divider_chain.spice (the
* Acceptance-Criteria reference netlist, generated by design/netlist.sh
* from design/divider_chain.sch) -- see divider_chain.py's own
* _instance_body() docstring for why a flat re-expression rather than
* that file's own hierarchical text: gf180mcu's LVS deck does not
* flatten a hierarchical schematic to match this block's flat GDS on
* its own. Every device/connection below traces to that generated
* file's own subckt bodies (div23_cell, nor2_3v3, inv_3v3, nand2_3v3,
* nand3_3v3, inv2x_3v3, dff_tg_3v3), via each of those modules' own
* independently-stated reference_netlist().
*
* Run LVS with --lvs_sub=VSS (layout/run_pv.py's own default): the NMOS
* body ties to the deck's synthesized global substrate net, which this
* flag names VSS -- see layout/README.md's "substrate-net gotcha".

.subckt divider_chain VCO P0 P1 P2 P3 P4 P5 SEL0 SEL1 SEL2 SEL3 SEL4 SEL5 DIVOUT FB VDD_DIV VSS
M_XD0_XN3_MPA XD0_SB MI0 VDD_DIV VDD_DIV pfet_03v3 L=0.28u W=2.5u
M_XD0_XN3_MPB XD0_SB P0 VDD_DIV VDD_DIV pfet_03v3 L=0.28u W=2.5u
M_XD0_XN3_MPC XD0_SB MO0 VDD_DIV VDD_DIV pfet_03v3 L=0.28u W=2.5u
M_XD0_XN3_MNA XD0_SB MI0 XD0_XN3_NM1 VSS nfet_03v3 L=0.28u W=3u
M_XD0_XN3_MNB XD0_XN3_NM1 P0 XD0_XN3_NM2 VSS nfet_03v3 L=0.28u W=3u
M_XD0_XN3_MNC XD0_XN3_NM2 MO0 VSS VSS nfet_03v3 L=0.28u W=3u
M_XD0_XN2Q_MPA XD0_DQN XD0_QB VDD_DIV VDD_DIV pfet_03v3 L=0.28u W=2.5u
M_XD0_XN2Q_MPB XD0_DQN XD0_SB VDD_DIV VDD_DIV pfet_03v3 L=0.28u W=2.5u
M_XD0_XN2Q_MNA XD0_DQN XD0_QB XD0_XN2Q_NMID VSS nfet_03v3 L=0.28u W=2u
M_XD0_XN2Q_MNB XD0_XN2Q_NMID XD0_SB VSS VSS nfet_03v3 L=0.28u W=2u
M_XD0_XIQ_MP XD0_DQ XD0_DQN VDD_DIV VDD_DIV pfet_03v3 L=0.28u W=2.5u
M_XD0_XIQ_MN XD0_DQ XD0_DQN VSS VSS nfet_03v3 L=0.28u W=1u
M_XD0_XFQ_ICKB_P XD0_XFQ_CKB VCO VDD_DIV VDD_DIV pfet_03v3 L=0.28u W=2.5u
M_XD0_XFQ_ICKB_N XD0_XFQ_CKB VCO VSS VSS nfet_03v3 L=0.28u W=1u
M_XD0_XFQ_ICKBB_P XD0_XFQ_CKBB XD0_XFQ_CKB VDD_DIV VDD_DIV pfet_03v3 L=0.28u W=2.5u
M_XD0_XFQ_ICKBB_N XD0_XFQ_CKBB XD0_XFQ_CKB VSS VSS nfet_03v3 L=0.28u W=1u
M_XD0_XFQ_TGMI_P XD0_XFQ_NM XD0_XFQ_CKBB XD0_DQ VDD_DIV pfet_03v3 L=0.28u W=2.5u
M_XD0_XFQ_TGMI_N XD0_DQ XD0_XFQ_CKB XD0_XFQ_NM VSS nfet_03v3 L=0.28u W=1u
M_XD0_XFQ_IA_P XD0_XFQ_NMA XD0_XFQ_NM VDD_DIV VDD_DIV pfet_03v3 L=0.28u W=2.5u
M_XD0_XFQ_IA_N XD0_XFQ_NMA XD0_XFQ_NM VSS VSS nfet_03v3 L=0.28u W=1u
M_XD0_XFQ_IB_P XD0_XFQ_NMB XD0_XFQ_NMA VDD_DIV VDD_DIV pfet_03v3 L=0.28u W=2.5u
M_XD0_XFQ_IB_N XD0_XFQ_NMB XD0_XFQ_NMA VSS VSS nfet_03v3 L=0.28u W=1u
M_XD0_XFQ_TGMF_P XD0_XFQ_NM XD0_XFQ_CKB XD0_XFQ_NMB VDD_DIV pfet_03v3 L=0.28u W=2.5u
M_XD0_XFQ_TGMF_N XD0_XFQ_NMB XD0_XFQ_CKBB XD0_XFQ_NM VSS nfet_03v3 L=0.28u W=1u
M_XD0_XFQ_TGSI_P XD0_XFQ_NS XD0_XFQ_CKB XD0_XFQ_NMA VDD_DIV pfet_03v3 L=0.28u W=2.5u
M_XD0_XFQ_TGSI_N XD0_XFQ_NMA XD0_XFQ_CKBB XD0_XFQ_NS VSS nfet_03v3 L=0.28u W=1u
M_XD0_XFQ_IC_P XD0_Q XD0_XFQ_NS VDD_DIV VDD_DIV pfet_03v3 L=0.28u W=2.5u
M_XD0_XFQ_IC_N XD0_Q XD0_XFQ_NS VSS VSS nfet_03v3 L=0.28u W=1u
M_XD0_XFQ_ID_P XD0_QB XD0_Q VDD_DIV VDD_DIV pfet_03v3 L=0.28u W=2.5u
M_XD0_XFQ_ID_N XD0_QB XD0_Q VSS VSS nfet_03v3 L=0.28u W=1u
M_XD0_XFQ_TGSF_P XD0_XFQ_NS XD0_XFQ_CKBB XD0_QB VDD_DIV pfet_03v3 L=0.28u W=2.5u
M_XD0_XFQ_TGSF_N XD0_QB XD0_XFQ_CKB XD0_XFQ_NS VSS nfet_03v3 L=0.28u W=1u
M_XD0_XICKO_MP CK1 XD0_QB VDD_DIV VDD_DIV pfet_03v3 L=0.28u W=5u
M_XD0_XICKO_MN CK1 XD0_QB VSS VSS nfet_03v3 L=0.28u W=2u
M_XD0_XN2M_MPA XD0_NMO MI0 VDD_DIV VDD_DIV pfet_03v3 L=0.28u W=2.5u
M_XD0_XN2M_MPB XD0_NMO XD0_Q VDD_DIV VDD_DIV pfet_03v3 L=0.28u W=2.5u
M_XD0_XN2M_MNA XD0_NMO MI0 XD0_XN2M_NMID VSS nfet_03v3 L=0.28u W=2u
M_XD0_XN2M_MNB XD0_XN2M_NMID XD0_Q VSS VSS nfet_03v3 L=0.28u W=2u
M_XD0_XIM_MP XD0_DMO XD0_NMO VDD_DIV VDD_DIV pfet_03v3 L=0.28u W=2.5u
M_XD0_XIM_MN XD0_DMO XD0_NMO VSS VSS nfet_03v3 L=0.28u W=1u
M_XD0_XFMO_ICKB_P XD0_XFMO_CKB VCO VDD_DIV VDD_DIV pfet_03v3 L=0.28u W=2.5u
M_XD0_XFMO_ICKB_N XD0_XFMO_CKB VCO VSS VSS nfet_03v3 L=0.28u W=1u
M_XD0_XFMO_ICKBB_P XD0_XFMO_CKBB XD0_XFMO_CKB VDD_DIV VDD_DIV pfet_03v3 L=0.28u W=2.5u
M_XD0_XFMO_ICKBB_N XD0_XFMO_CKBB XD0_XFMO_CKB VSS VSS nfet_03v3 L=0.28u W=1u
M_XD0_XFMO_TGMI_P XD0_XFMO_NM XD0_XFMO_CKBB XD0_DMO VDD_DIV pfet_03v3 L=0.28u W=2.5u
M_XD0_XFMO_TGMI_N XD0_DMO XD0_XFMO_CKB XD0_XFMO_NM VSS nfet_03v3 L=0.28u W=1u
M_XD0_XFMO_IA_P XD0_XFMO_NMA XD0_XFMO_NM VDD_DIV VDD_DIV pfet_03v3 L=0.28u W=2.5u
M_XD0_XFMO_IA_N XD0_XFMO_NMA XD0_XFMO_NM VSS VSS nfet_03v3 L=0.28u W=1u
M_XD0_XFMO_IB_P XD0_XFMO_NMB XD0_XFMO_NMA VDD_DIV VDD_DIV pfet_03v3 L=0.28u W=2.5u
M_XD0_XFMO_IB_N XD0_XFMO_NMB XD0_XFMO_NMA VSS VSS nfet_03v3 L=0.28u W=1u
M_XD0_XFMO_TGMF_P XD0_XFMO_NM XD0_XFMO_CKB XD0_XFMO_NMB VDD_DIV pfet_03v3 L=0.28u W=2.5u
M_XD0_XFMO_TGMF_N XD0_XFMO_NMB XD0_XFMO_CKBB XD0_XFMO_NM VSS nfet_03v3 L=0.28u W=1u
M_XD0_XFMO_TGSI_P XD0_XFMO_NS XD0_XFMO_CKB XD0_XFMO_NMA VDD_DIV pfet_03v3 L=0.28u W=2.5u
M_XD0_XFMO_TGSI_N XD0_XFMO_NMA XD0_XFMO_CKBB XD0_XFMO_NS VSS nfet_03v3 L=0.28u W=1u
M_XD0_XFMO_IC_P MO0 XD0_XFMO_NS VDD_DIV VDD_DIV pfet_03v3 L=0.28u W=2.5u
M_XD0_XFMO_IC_N MO0 XD0_XFMO_NS VSS VSS nfet_03v3 L=0.28u W=1u
M_XD0_XFMO_ID_P XD0_MOB MO0 VDD_DIV VDD_DIV pfet_03v3 L=0.28u W=2.5u
M_XD0_XFMO_ID_N XD0_MOB MO0 VSS VSS nfet_03v3 L=0.28u W=1u
M_XD0_XFMO_TGSF_P XD0_XFMO_NS XD0_XFMO_CKBB XD0_MOB VDD_DIV pfet_03v3 L=0.28u W=2.5u
M_XD0_XFMO_TGSF_N XD0_MOB XD0_XFMO_CKB XD0_XFMO_NS VSS nfet_03v3 L=0.28u W=1u
M_XD1_XN3_MPA XD1_SB MI1 VDD_DIV VDD_DIV pfet_03v3 L=0.28u W=2.5u
M_XD1_XN3_MPB XD1_SB P1 VDD_DIV VDD_DIV pfet_03v3 L=0.28u W=2.5u
M_XD1_XN3_MPC XD1_SB MO1 VDD_DIV VDD_DIV pfet_03v3 L=0.28u W=2.5u
M_XD1_XN3_MNA XD1_SB MI1 XD1_XN3_NM1 VSS nfet_03v3 L=0.28u W=3u
M_XD1_XN3_MNB XD1_XN3_NM1 P1 XD1_XN3_NM2 VSS nfet_03v3 L=0.28u W=3u
M_XD1_XN3_MNC XD1_XN3_NM2 MO1 VSS VSS nfet_03v3 L=0.28u W=3u
M_XD1_XN2Q_MPA XD1_DQN XD1_QB VDD_DIV VDD_DIV pfet_03v3 L=0.28u W=2.5u
M_XD1_XN2Q_MPB XD1_DQN XD1_SB VDD_DIV VDD_DIV pfet_03v3 L=0.28u W=2.5u
M_XD1_XN2Q_MNA XD1_DQN XD1_QB XD1_XN2Q_NMID VSS nfet_03v3 L=0.28u W=2u
M_XD1_XN2Q_MNB XD1_XN2Q_NMID XD1_SB VSS VSS nfet_03v3 L=0.28u W=2u
M_XD1_XIQ_MP XD1_DQ XD1_DQN VDD_DIV VDD_DIV pfet_03v3 L=0.28u W=2.5u
M_XD1_XIQ_MN XD1_DQ XD1_DQN VSS VSS nfet_03v3 L=0.28u W=1u
M_XD1_XFQ_ICKB_P XD1_XFQ_CKB CK1 VDD_DIV VDD_DIV pfet_03v3 L=0.28u W=2.5u
M_XD1_XFQ_ICKB_N XD1_XFQ_CKB CK1 VSS VSS nfet_03v3 L=0.28u W=1u
M_XD1_XFQ_ICKBB_P XD1_XFQ_CKBB XD1_XFQ_CKB VDD_DIV VDD_DIV pfet_03v3 L=0.28u W=2.5u
M_XD1_XFQ_ICKBB_N XD1_XFQ_CKBB XD1_XFQ_CKB VSS VSS nfet_03v3 L=0.28u W=1u
M_XD1_XFQ_TGMI_P XD1_XFQ_NM XD1_XFQ_CKBB XD1_DQ VDD_DIV pfet_03v3 L=0.28u W=2.5u
M_XD1_XFQ_TGMI_N XD1_DQ XD1_XFQ_CKB XD1_XFQ_NM VSS nfet_03v3 L=0.28u W=1u
M_XD1_XFQ_IA_P XD1_XFQ_NMA XD1_XFQ_NM VDD_DIV VDD_DIV pfet_03v3 L=0.28u W=2.5u
M_XD1_XFQ_IA_N XD1_XFQ_NMA XD1_XFQ_NM VSS VSS nfet_03v3 L=0.28u W=1u
M_XD1_XFQ_IB_P XD1_XFQ_NMB XD1_XFQ_NMA VDD_DIV VDD_DIV pfet_03v3 L=0.28u W=2.5u
M_XD1_XFQ_IB_N XD1_XFQ_NMB XD1_XFQ_NMA VSS VSS nfet_03v3 L=0.28u W=1u
M_XD1_XFQ_TGMF_P XD1_XFQ_NM XD1_XFQ_CKB XD1_XFQ_NMB VDD_DIV pfet_03v3 L=0.28u W=2.5u
M_XD1_XFQ_TGMF_N XD1_XFQ_NMB XD1_XFQ_CKBB XD1_XFQ_NM VSS nfet_03v3 L=0.28u W=1u
M_XD1_XFQ_TGSI_P XD1_XFQ_NS XD1_XFQ_CKB XD1_XFQ_NMA VDD_DIV pfet_03v3 L=0.28u W=2.5u
M_XD1_XFQ_TGSI_N XD1_XFQ_NMA XD1_XFQ_CKBB XD1_XFQ_NS VSS nfet_03v3 L=0.28u W=1u
M_XD1_XFQ_IC_P XD1_Q XD1_XFQ_NS VDD_DIV VDD_DIV pfet_03v3 L=0.28u W=2.5u
M_XD1_XFQ_IC_N XD1_Q XD1_XFQ_NS VSS VSS nfet_03v3 L=0.28u W=1u
M_XD1_XFQ_ID_P XD1_QB XD1_Q VDD_DIV VDD_DIV pfet_03v3 L=0.28u W=2.5u
M_XD1_XFQ_ID_N XD1_QB XD1_Q VSS VSS nfet_03v3 L=0.28u W=1u
M_XD1_XFQ_TGSF_P XD1_XFQ_NS XD1_XFQ_CKBB XD1_QB VDD_DIV pfet_03v3 L=0.28u W=2.5u
M_XD1_XFQ_TGSF_N XD1_QB XD1_XFQ_CKB XD1_XFQ_NS VSS nfet_03v3 L=0.28u W=1u
M_XD1_XICKO_MP CK2 XD1_QB VDD_DIV VDD_DIV pfet_03v3 L=0.28u W=5u
M_XD1_XICKO_MN CK2 XD1_QB VSS VSS nfet_03v3 L=0.28u W=2u
M_XD1_XN2M_MPA XD1_NMO MI1 VDD_DIV VDD_DIV pfet_03v3 L=0.28u W=2.5u
M_XD1_XN2M_MPB XD1_NMO XD1_Q VDD_DIV VDD_DIV pfet_03v3 L=0.28u W=2.5u
M_XD1_XN2M_MNA XD1_NMO MI1 XD1_XN2M_NMID VSS nfet_03v3 L=0.28u W=2u
M_XD1_XN2M_MNB XD1_XN2M_NMID XD1_Q VSS VSS nfet_03v3 L=0.28u W=2u
M_XD1_XIM_MP XD1_DMO XD1_NMO VDD_DIV VDD_DIV pfet_03v3 L=0.28u W=2.5u
M_XD1_XIM_MN XD1_DMO XD1_NMO VSS VSS nfet_03v3 L=0.28u W=1u
M_XD1_XFMO_ICKB_P XD1_XFMO_CKB CK1 VDD_DIV VDD_DIV pfet_03v3 L=0.28u W=2.5u
M_XD1_XFMO_ICKB_N XD1_XFMO_CKB CK1 VSS VSS nfet_03v3 L=0.28u W=1u
M_XD1_XFMO_ICKBB_P XD1_XFMO_CKBB XD1_XFMO_CKB VDD_DIV VDD_DIV pfet_03v3 L=0.28u W=2.5u
M_XD1_XFMO_ICKBB_N XD1_XFMO_CKBB XD1_XFMO_CKB VSS VSS nfet_03v3 L=0.28u W=1u
M_XD1_XFMO_TGMI_P XD1_XFMO_NM XD1_XFMO_CKBB XD1_DMO VDD_DIV pfet_03v3 L=0.28u W=2.5u
M_XD1_XFMO_TGMI_N XD1_DMO XD1_XFMO_CKB XD1_XFMO_NM VSS nfet_03v3 L=0.28u W=1u
M_XD1_XFMO_IA_P XD1_XFMO_NMA XD1_XFMO_NM VDD_DIV VDD_DIV pfet_03v3 L=0.28u W=2.5u
M_XD1_XFMO_IA_N XD1_XFMO_NMA XD1_XFMO_NM VSS VSS nfet_03v3 L=0.28u W=1u
M_XD1_XFMO_IB_P XD1_XFMO_NMB XD1_XFMO_NMA VDD_DIV VDD_DIV pfet_03v3 L=0.28u W=2.5u
M_XD1_XFMO_IB_N XD1_XFMO_NMB XD1_XFMO_NMA VSS VSS nfet_03v3 L=0.28u W=1u
M_XD1_XFMO_TGMF_P XD1_XFMO_NM XD1_XFMO_CKB XD1_XFMO_NMB VDD_DIV pfet_03v3 L=0.28u W=2.5u
M_XD1_XFMO_TGMF_N XD1_XFMO_NMB XD1_XFMO_CKBB XD1_XFMO_NM VSS nfet_03v3 L=0.28u W=1u
M_XD1_XFMO_TGSI_P XD1_XFMO_NS XD1_XFMO_CKB XD1_XFMO_NMA VDD_DIV pfet_03v3 L=0.28u W=2.5u
M_XD1_XFMO_TGSI_N XD1_XFMO_NMA XD1_XFMO_CKBB XD1_XFMO_NS VSS nfet_03v3 L=0.28u W=1u
M_XD1_XFMO_IC_P MO1 XD1_XFMO_NS VDD_DIV VDD_DIV pfet_03v3 L=0.28u W=2.5u
M_XD1_XFMO_IC_N MO1 XD1_XFMO_NS VSS VSS nfet_03v3 L=0.28u W=1u
M_XD1_XFMO_ID_P XD1_MOB MO1 VDD_DIV VDD_DIV pfet_03v3 L=0.28u W=2.5u
M_XD1_XFMO_ID_N XD1_MOB MO1 VSS VSS nfet_03v3 L=0.28u W=1u
M_XD1_XFMO_TGSF_P XD1_XFMO_NS XD1_XFMO_CKBB XD1_MOB VDD_DIV pfet_03v3 L=0.28u W=2.5u
M_XD1_XFMO_TGSF_N XD1_MOB XD1_XFMO_CKB XD1_XFMO_NS VSS nfet_03v3 L=0.28u W=1u
M_XD2_XN3_MPA XD2_SB MI2 VDD_DIV VDD_DIV pfet_03v3 L=0.28u W=2.5u
M_XD2_XN3_MPB XD2_SB P2 VDD_DIV VDD_DIV pfet_03v3 L=0.28u W=2.5u
M_XD2_XN3_MPC XD2_SB MO2 VDD_DIV VDD_DIV pfet_03v3 L=0.28u W=2.5u
M_XD2_XN3_MNA XD2_SB MI2 XD2_XN3_NM1 VSS nfet_03v3 L=0.28u W=3u
M_XD2_XN3_MNB XD2_XN3_NM1 P2 XD2_XN3_NM2 VSS nfet_03v3 L=0.28u W=3u
M_XD2_XN3_MNC XD2_XN3_NM2 MO2 VSS VSS nfet_03v3 L=0.28u W=3u
M_XD2_XN2Q_MPA XD2_DQN XD2_QB VDD_DIV VDD_DIV pfet_03v3 L=0.28u W=2.5u
M_XD2_XN2Q_MPB XD2_DQN XD2_SB VDD_DIV VDD_DIV pfet_03v3 L=0.28u W=2.5u
M_XD2_XN2Q_MNA XD2_DQN XD2_QB XD2_XN2Q_NMID VSS nfet_03v3 L=0.28u W=2u
M_XD2_XN2Q_MNB XD2_XN2Q_NMID XD2_SB VSS VSS nfet_03v3 L=0.28u W=2u
M_XD2_XIQ_MP XD2_DQ XD2_DQN VDD_DIV VDD_DIV pfet_03v3 L=0.28u W=2.5u
M_XD2_XIQ_MN XD2_DQ XD2_DQN VSS VSS nfet_03v3 L=0.28u W=1u
M_XD2_XFQ_ICKB_P XD2_XFQ_CKB CK2 VDD_DIV VDD_DIV pfet_03v3 L=0.28u W=2.5u
M_XD2_XFQ_ICKB_N XD2_XFQ_CKB CK2 VSS VSS nfet_03v3 L=0.28u W=1u
M_XD2_XFQ_ICKBB_P XD2_XFQ_CKBB XD2_XFQ_CKB VDD_DIV VDD_DIV pfet_03v3 L=0.28u W=2.5u
M_XD2_XFQ_ICKBB_N XD2_XFQ_CKBB XD2_XFQ_CKB VSS VSS nfet_03v3 L=0.28u W=1u
M_XD2_XFQ_TGMI_P XD2_XFQ_NM XD2_XFQ_CKBB XD2_DQ VDD_DIV pfet_03v3 L=0.28u W=2.5u
M_XD2_XFQ_TGMI_N XD2_DQ XD2_XFQ_CKB XD2_XFQ_NM VSS nfet_03v3 L=0.28u W=1u
M_XD2_XFQ_IA_P XD2_XFQ_NMA XD2_XFQ_NM VDD_DIV VDD_DIV pfet_03v3 L=0.28u W=2.5u
M_XD2_XFQ_IA_N XD2_XFQ_NMA XD2_XFQ_NM VSS VSS nfet_03v3 L=0.28u W=1u
M_XD2_XFQ_IB_P XD2_XFQ_NMB XD2_XFQ_NMA VDD_DIV VDD_DIV pfet_03v3 L=0.28u W=2.5u
M_XD2_XFQ_IB_N XD2_XFQ_NMB XD2_XFQ_NMA VSS VSS nfet_03v3 L=0.28u W=1u
M_XD2_XFQ_TGMF_P XD2_XFQ_NM XD2_XFQ_CKB XD2_XFQ_NMB VDD_DIV pfet_03v3 L=0.28u W=2.5u
M_XD2_XFQ_TGMF_N XD2_XFQ_NMB XD2_XFQ_CKBB XD2_XFQ_NM VSS nfet_03v3 L=0.28u W=1u
M_XD2_XFQ_TGSI_P XD2_XFQ_NS XD2_XFQ_CKB XD2_XFQ_NMA VDD_DIV pfet_03v3 L=0.28u W=2.5u
M_XD2_XFQ_TGSI_N XD2_XFQ_NMA XD2_XFQ_CKBB XD2_XFQ_NS VSS nfet_03v3 L=0.28u W=1u
M_XD2_XFQ_IC_P XD2_Q XD2_XFQ_NS VDD_DIV VDD_DIV pfet_03v3 L=0.28u W=2.5u
M_XD2_XFQ_IC_N XD2_Q XD2_XFQ_NS VSS VSS nfet_03v3 L=0.28u W=1u
M_XD2_XFQ_ID_P XD2_QB XD2_Q VDD_DIV VDD_DIV pfet_03v3 L=0.28u W=2.5u
M_XD2_XFQ_ID_N XD2_QB XD2_Q VSS VSS nfet_03v3 L=0.28u W=1u
M_XD2_XFQ_TGSF_P XD2_XFQ_NS XD2_XFQ_CKBB XD2_QB VDD_DIV pfet_03v3 L=0.28u W=2.5u
M_XD2_XFQ_TGSF_N XD2_QB XD2_XFQ_CKB XD2_XFQ_NS VSS nfet_03v3 L=0.28u W=1u
M_XD2_XICKO_MP CK3 XD2_QB VDD_DIV VDD_DIV pfet_03v3 L=0.28u W=5u
M_XD2_XICKO_MN CK3 XD2_QB VSS VSS nfet_03v3 L=0.28u W=2u
M_XD2_XN2M_MPA XD2_NMO MI2 VDD_DIV VDD_DIV pfet_03v3 L=0.28u W=2.5u
M_XD2_XN2M_MPB XD2_NMO XD2_Q VDD_DIV VDD_DIV pfet_03v3 L=0.28u W=2.5u
M_XD2_XN2M_MNA XD2_NMO MI2 XD2_XN2M_NMID VSS nfet_03v3 L=0.28u W=2u
M_XD2_XN2M_MNB XD2_XN2M_NMID XD2_Q VSS VSS nfet_03v3 L=0.28u W=2u
M_XD2_XIM_MP XD2_DMO XD2_NMO VDD_DIV VDD_DIV pfet_03v3 L=0.28u W=2.5u
M_XD2_XIM_MN XD2_DMO XD2_NMO VSS VSS nfet_03v3 L=0.28u W=1u
M_XD2_XFMO_ICKB_P XD2_XFMO_CKB CK2 VDD_DIV VDD_DIV pfet_03v3 L=0.28u W=2.5u
M_XD2_XFMO_ICKB_N XD2_XFMO_CKB CK2 VSS VSS nfet_03v3 L=0.28u W=1u
M_XD2_XFMO_ICKBB_P XD2_XFMO_CKBB XD2_XFMO_CKB VDD_DIV VDD_DIV pfet_03v3 L=0.28u W=2.5u
M_XD2_XFMO_ICKBB_N XD2_XFMO_CKBB XD2_XFMO_CKB VSS VSS nfet_03v3 L=0.28u W=1u
M_XD2_XFMO_TGMI_P XD2_XFMO_NM XD2_XFMO_CKBB XD2_DMO VDD_DIV pfet_03v3 L=0.28u W=2.5u
M_XD2_XFMO_TGMI_N XD2_DMO XD2_XFMO_CKB XD2_XFMO_NM VSS nfet_03v3 L=0.28u W=1u
M_XD2_XFMO_IA_P XD2_XFMO_NMA XD2_XFMO_NM VDD_DIV VDD_DIV pfet_03v3 L=0.28u W=2.5u
M_XD2_XFMO_IA_N XD2_XFMO_NMA XD2_XFMO_NM VSS VSS nfet_03v3 L=0.28u W=1u
M_XD2_XFMO_IB_P XD2_XFMO_NMB XD2_XFMO_NMA VDD_DIV VDD_DIV pfet_03v3 L=0.28u W=2.5u
M_XD2_XFMO_IB_N XD2_XFMO_NMB XD2_XFMO_NMA VSS VSS nfet_03v3 L=0.28u W=1u
M_XD2_XFMO_TGMF_P XD2_XFMO_NM XD2_XFMO_CKB XD2_XFMO_NMB VDD_DIV pfet_03v3 L=0.28u W=2.5u
M_XD2_XFMO_TGMF_N XD2_XFMO_NMB XD2_XFMO_CKBB XD2_XFMO_NM VSS nfet_03v3 L=0.28u W=1u
M_XD2_XFMO_TGSI_P XD2_XFMO_NS XD2_XFMO_CKB XD2_XFMO_NMA VDD_DIV pfet_03v3 L=0.28u W=2.5u
M_XD2_XFMO_TGSI_N XD2_XFMO_NMA XD2_XFMO_CKBB XD2_XFMO_NS VSS nfet_03v3 L=0.28u W=1u
M_XD2_XFMO_IC_P MO2 XD2_XFMO_NS VDD_DIV VDD_DIV pfet_03v3 L=0.28u W=2.5u
M_XD2_XFMO_IC_N MO2 XD2_XFMO_NS VSS VSS nfet_03v3 L=0.28u W=1u
M_XD2_XFMO_ID_P XD2_MOB MO2 VDD_DIV VDD_DIV pfet_03v3 L=0.28u W=2.5u
M_XD2_XFMO_ID_N XD2_MOB MO2 VSS VSS nfet_03v3 L=0.28u W=1u
M_XD2_XFMO_TGSF_P XD2_XFMO_NS XD2_XFMO_CKBB XD2_MOB VDD_DIV pfet_03v3 L=0.28u W=2.5u
M_XD2_XFMO_TGSF_N XD2_MOB XD2_XFMO_CKB XD2_XFMO_NS VSS nfet_03v3 L=0.28u W=1u
M_XD3_XN3_MPA XD3_SB MI3 VDD_DIV VDD_DIV pfet_03v3 L=0.28u W=2.5u
M_XD3_XN3_MPB XD3_SB P3 VDD_DIV VDD_DIV pfet_03v3 L=0.28u W=2.5u
M_XD3_XN3_MPC XD3_SB MO3 VDD_DIV VDD_DIV pfet_03v3 L=0.28u W=2.5u
M_XD3_XN3_MNA XD3_SB MI3 XD3_XN3_NM1 VSS nfet_03v3 L=0.28u W=3u
M_XD3_XN3_MNB XD3_XN3_NM1 P3 XD3_XN3_NM2 VSS nfet_03v3 L=0.28u W=3u
M_XD3_XN3_MNC XD3_XN3_NM2 MO3 VSS VSS nfet_03v3 L=0.28u W=3u
M_XD3_XN2Q_MPA XD3_DQN XD3_QB VDD_DIV VDD_DIV pfet_03v3 L=0.28u W=2.5u
M_XD3_XN2Q_MPB XD3_DQN XD3_SB VDD_DIV VDD_DIV pfet_03v3 L=0.28u W=2.5u
M_XD3_XN2Q_MNA XD3_DQN XD3_QB XD3_XN2Q_NMID VSS nfet_03v3 L=0.28u W=2u
M_XD3_XN2Q_MNB XD3_XN2Q_NMID XD3_SB VSS VSS nfet_03v3 L=0.28u W=2u
M_XD3_XIQ_MP XD3_DQ XD3_DQN VDD_DIV VDD_DIV pfet_03v3 L=0.28u W=2.5u
M_XD3_XIQ_MN XD3_DQ XD3_DQN VSS VSS nfet_03v3 L=0.28u W=1u
M_XD3_XFQ_ICKB_P XD3_XFQ_CKB CK3 VDD_DIV VDD_DIV pfet_03v3 L=0.28u W=2.5u
M_XD3_XFQ_ICKB_N XD3_XFQ_CKB CK3 VSS VSS nfet_03v3 L=0.28u W=1u
M_XD3_XFQ_ICKBB_P XD3_XFQ_CKBB XD3_XFQ_CKB VDD_DIV VDD_DIV pfet_03v3 L=0.28u W=2.5u
M_XD3_XFQ_ICKBB_N XD3_XFQ_CKBB XD3_XFQ_CKB VSS VSS nfet_03v3 L=0.28u W=1u
M_XD3_XFQ_TGMI_P XD3_XFQ_NM XD3_XFQ_CKBB XD3_DQ VDD_DIV pfet_03v3 L=0.28u W=2.5u
M_XD3_XFQ_TGMI_N XD3_DQ XD3_XFQ_CKB XD3_XFQ_NM VSS nfet_03v3 L=0.28u W=1u
M_XD3_XFQ_IA_P XD3_XFQ_NMA XD3_XFQ_NM VDD_DIV VDD_DIV pfet_03v3 L=0.28u W=2.5u
M_XD3_XFQ_IA_N XD3_XFQ_NMA XD3_XFQ_NM VSS VSS nfet_03v3 L=0.28u W=1u
M_XD3_XFQ_IB_P XD3_XFQ_NMB XD3_XFQ_NMA VDD_DIV VDD_DIV pfet_03v3 L=0.28u W=2.5u
M_XD3_XFQ_IB_N XD3_XFQ_NMB XD3_XFQ_NMA VSS VSS nfet_03v3 L=0.28u W=1u
M_XD3_XFQ_TGMF_P XD3_XFQ_NM XD3_XFQ_CKB XD3_XFQ_NMB VDD_DIV pfet_03v3 L=0.28u W=2.5u
M_XD3_XFQ_TGMF_N XD3_XFQ_NMB XD3_XFQ_CKBB XD3_XFQ_NM VSS nfet_03v3 L=0.28u W=1u
M_XD3_XFQ_TGSI_P XD3_XFQ_NS XD3_XFQ_CKB XD3_XFQ_NMA VDD_DIV pfet_03v3 L=0.28u W=2.5u
M_XD3_XFQ_TGSI_N XD3_XFQ_NMA XD3_XFQ_CKBB XD3_XFQ_NS VSS nfet_03v3 L=0.28u W=1u
M_XD3_XFQ_IC_P XD3_Q XD3_XFQ_NS VDD_DIV VDD_DIV pfet_03v3 L=0.28u W=2.5u
M_XD3_XFQ_IC_N XD3_Q XD3_XFQ_NS VSS VSS nfet_03v3 L=0.28u W=1u
M_XD3_XFQ_ID_P XD3_QB XD3_Q VDD_DIV VDD_DIV pfet_03v3 L=0.28u W=2.5u
M_XD3_XFQ_ID_N XD3_QB XD3_Q VSS VSS nfet_03v3 L=0.28u W=1u
M_XD3_XFQ_TGSF_P XD3_XFQ_NS XD3_XFQ_CKBB XD3_QB VDD_DIV pfet_03v3 L=0.28u W=2.5u
M_XD3_XFQ_TGSF_N XD3_QB XD3_XFQ_CKB XD3_XFQ_NS VSS nfet_03v3 L=0.28u W=1u
M_XD3_XICKO_MP CK4 XD3_QB VDD_DIV VDD_DIV pfet_03v3 L=0.28u W=5u
M_XD3_XICKO_MN CK4 XD3_QB VSS VSS nfet_03v3 L=0.28u W=2u
M_XD3_XN2M_MPA XD3_NMO MI3 VDD_DIV VDD_DIV pfet_03v3 L=0.28u W=2.5u
M_XD3_XN2M_MPB XD3_NMO XD3_Q VDD_DIV VDD_DIV pfet_03v3 L=0.28u W=2.5u
M_XD3_XN2M_MNA XD3_NMO MI3 XD3_XN2M_NMID VSS nfet_03v3 L=0.28u W=2u
M_XD3_XN2M_MNB XD3_XN2M_NMID XD3_Q VSS VSS nfet_03v3 L=0.28u W=2u
M_XD3_XIM_MP XD3_DMO XD3_NMO VDD_DIV VDD_DIV pfet_03v3 L=0.28u W=2.5u
M_XD3_XIM_MN XD3_DMO XD3_NMO VSS VSS nfet_03v3 L=0.28u W=1u
M_XD3_XFMO_ICKB_P XD3_XFMO_CKB CK3 VDD_DIV VDD_DIV pfet_03v3 L=0.28u W=2.5u
M_XD3_XFMO_ICKB_N XD3_XFMO_CKB CK3 VSS VSS nfet_03v3 L=0.28u W=1u
M_XD3_XFMO_ICKBB_P XD3_XFMO_CKBB XD3_XFMO_CKB VDD_DIV VDD_DIV pfet_03v3 L=0.28u W=2.5u
M_XD3_XFMO_ICKBB_N XD3_XFMO_CKBB XD3_XFMO_CKB VSS VSS nfet_03v3 L=0.28u W=1u
M_XD3_XFMO_TGMI_P XD3_XFMO_NM XD3_XFMO_CKBB XD3_DMO VDD_DIV pfet_03v3 L=0.28u W=2.5u
M_XD3_XFMO_TGMI_N XD3_DMO XD3_XFMO_CKB XD3_XFMO_NM VSS nfet_03v3 L=0.28u W=1u
M_XD3_XFMO_IA_P XD3_XFMO_NMA XD3_XFMO_NM VDD_DIV VDD_DIV pfet_03v3 L=0.28u W=2.5u
M_XD3_XFMO_IA_N XD3_XFMO_NMA XD3_XFMO_NM VSS VSS nfet_03v3 L=0.28u W=1u
M_XD3_XFMO_IB_P XD3_XFMO_NMB XD3_XFMO_NMA VDD_DIV VDD_DIV pfet_03v3 L=0.28u W=2.5u
M_XD3_XFMO_IB_N XD3_XFMO_NMB XD3_XFMO_NMA VSS VSS nfet_03v3 L=0.28u W=1u
M_XD3_XFMO_TGMF_P XD3_XFMO_NM XD3_XFMO_CKB XD3_XFMO_NMB VDD_DIV pfet_03v3 L=0.28u W=2.5u
M_XD3_XFMO_TGMF_N XD3_XFMO_NMB XD3_XFMO_CKBB XD3_XFMO_NM VSS nfet_03v3 L=0.28u W=1u
M_XD3_XFMO_TGSI_P XD3_XFMO_NS XD3_XFMO_CKB XD3_XFMO_NMA VDD_DIV pfet_03v3 L=0.28u W=2.5u
M_XD3_XFMO_TGSI_N XD3_XFMO_NMA XD3_XFMO_CKBB XD3_XFMO_NS VSS nfet_03v3 L=0.28u W=1u
M_XD3_XFMO_IC_P MO3 XD3_XFMO_NS VDD_DIV VDD_DIV pfet_03v3 L=0.28u W=2.5u
M_XD3_XFMO_IC_N MO3 XD3_XFMO_NS VSS VSS nfet_03v3 L=0.28u W=1u
M_XD3_XFMO_ID_P XD3_MOB MO3 VDD_DIV VDD_DIV pfet_03v3 L=0.28u W=2.5u
M_XD3_XFMO_ID_N XD3_MOB MO3 VSS VSS nfet_03v3 L=0.28u W=1u
M_XD3_XFMO_TGSF_P XD3_XFMO_NS XD3_XFMO_CKBB XD3_MOB VDD_DIV pfet_03v3 L=0.28u W=2.5u
M_XD3_XFMO_TGSF_N XD3_MOB XD3_XFMO_CKB XD3_XFMO_NS VSS nfet_03v3 L=0.28u W=1u
M_XD4_XN3_MPA XD4_SB MI4 VDD_DIV VDD_DIV pfet_03v3 L=0.28u W=2.5u
M_XD4_XN3_MPB XD4_SB P4 VDD_DIV VDD_DIV pfet_03v3 L=0.28u W=2.5u
M_XD4_XN3_MPC XD4_SB MO4 VDD_DIV VDD_DIV pfet_03v3 L=0.28u W=2.5u
M_XD4_XN3_MNA XD4_SB MI4 XD4_XN3_NM1 VSS nfet_03v3 L=0.28u W=3u
M_XD4_XN3_MNB XD4_XN3_NM1 P4 XD4_XN3_NM2 VSS nfet_03v3 L=0.28u W=3u
M_XD4_XN3_MNC XD4_XN3_NM2 MO4 VSS VSS nfet_03v3 L=0.28u W=3u
M_XD4_XN2Q_MPA XD4_DQN XD4_QB VDD_DIV VDD_DIV pfet_03v3 L=0.28u W=2.5u
M_XD4_XN2Q_MPB XD4_DQN XD4_SB VDD_DIV VDD_DIV pfet_03v3 L=0.28u W=2.5u
M_XD4_XN2Q_MNA XD4_DQN XD4_QB XD4_XN2Q_NMID VSS nfet_03v3 L=0.28u W=2u
M_XD4_XN2Q_MNB XD4_XN2Q_NMID XD4_SB VSS VSS nfet_03v3 L=0.28u W=2u
M_XD4_XIQ_MP XD4_DQ XD4_DQN VDD_DIV VDD_DIV pfet_03v3 L=0.28u W=2.5u
M_XD4_XIQ_MN XD4_DQ XD4_DQN VSS VSS nfet_03v3 L=0.28u W=1u
M_XD4_XFQ_ICKB_P XD4_XFQ_CKB CK4 VDD_DIV VDD_DIV pfet_03v3 L=0.28u W=2.5u
M_XD4_XFQ_ICKB_N XD4_XFQ_CKB CK4 VSS VSS nfet_03v3 L=0.28u W=1u
M_XD4_XFQ_ICKBB_P XD4_XFQ_CKBB XD4_XFQ_CKB VDD_DIV VDD_DIV pfet_03v3 L=0.28u W=2.5u
M_XD4_XFQ_ICKBB_N XD4_XFQ_CKBB XD4_XFQ_CKB VSS VSS nfet_03v3 L=0.28u W=1u
M_XD4_XFQ_TGMI_P XD4_XFQ_NM XD4_XFQ_CKBB XD4_DQ VDD_DIV pfet_03v3 L=0.28u W=2.5u
M_XD4_XFQ_TGMI_N XD4_DQ XD4_XFQ_CKB XD4_XFQ_NM VSS nfet_03v3 L=0.28u W=1u
M_XD4_XFQ_IA_P XD4_XFQ_NMA XD4_XFQ_NM VDD_DIV VDD_DIV pfet_03v3 L=0.28u W=2.5u
M_XD4_XFQ_IA_N XD4_XFQ_NMA XD4_XFQ_NM VSS VSS nfet_03v3 L=0.28u W=1u
M_XD4_XFQ_IB_P XD4_XFQ_NMB XD4_XFQ_NMA VDD_DIV VDD_DIV pfet_03v3 L=0.28u W=2.5u
M_XD4_XFQ_IB_N XD4_XFQ_NMB XD4_XFQ_NMA VSS VSS nfet_03v3 L=0.28u W=1u
M_XD4_XFQ_TGMF_P XD4_XFQ_NM XD4_XFQ_CKB XD4_XFQ_NMB VDD_DIV pfet_03v3 L=0.28u W=2.5u
M_XD4_XFQ_TGMF_N XD4_XFQ_NMB XD4_XFQ_CKBB XD4_XFQ_NM VSS nfet_03v3 L=0.28u W=1u
M_XD4_XFQ_TGSI_P XD4_XFQ_NS XD4_XFQ_CKB XD4_XFQ_NMA VDD_DIV pfet_03v3 L=0.28u W=2.5u
M_XD4_XFQ_TGSI_N XD4_XFQ_NMA XD4_XFQ_CKBB XD4_XFQ_NS VSS nfet_03v3 L=0.28u W=1u
M_XD4_XFQ_IC_P XD4_Q XD4_XFQ_NS VDD_DIV VDD_DIV pfet_03v3 L=0.28u W=2.5u
M_XD4_XFQ_IC_N XD4_Q XD4_XFQ_NS VSS VSS nfet_03v3 L=0.28u W=1u
M_XD4_XFQ_ID_P XD4_QB XD4_Q VDD_DIV VDD_DIV pfet_03v3 L=0.28u W=2.5u
M_XD4_XFQ_ID_N XD4_QB XD4_Q VSS VSS nfet_03v3 L=0.28u W=1u
M_XD4_XFQ_TGSF_P XD4_XFQ_NS XD4_XFQ_CKBB XD4_QB VDD_DIV pfet_03v3 L=0.28u W=2.5u
M_XD4_XFQ_TGSF_N XD4_QB XD4_XFQ_CKB XD4_XFQ_NS VSS nfet_03v3 L=0.28u W=1u
M_XD4_XICKO_MP CK5 XD4_QB VDD_DIV VDD_DIV pfet_03v3 L=0.28u W=5u
M_XD4_XICKO_MN CK5 XD4_QB VSS VSS nfet_03v3 L=0.28u W=2u
M_XD4_XN2M_MPA XD4_NMO MI4 VDD_DIV VDD_DIV pfet_03v3 L=0.28u W=2.5u
M_XD4_XN2M_MPB XD4_NMO XD4_Q VDD_DIV VDD_DIV pfet_03v3 L=0.28u W=2.5u
M_XD4_XN2M_MNA XD4_NMO MI4 XD4_XN2M_NMID VSS nfet_03v3 L=0.28u W=2u
M_XD4_XN2M_MNB XD4_XN2M_NMID XD4_Q VSS VSS nfet_03v3 L=0.28u W=2u
M_XD4_XIM_MP XD4_DMO XD4_NMO VDD_DIV VDD_DIV pfet_03v3 L=0.28u W=2.5u
M_XD4_XIM_MN XD4_DMO XD4_NMO VSS VSS nfet_03v3 L=0.28u W=1u
M_XD4_XFMO_ICKB_P XD4_XFMO_CKB CK4 VDD_DIV VDD_DIV pfet_03v3 L=0.28u W=2.5u
M_XD4_XFMO_ICKB_N XD4_XFMO_CKB CK4 VSS VSS nfet_03v3 L=0.28u W=1u
M_XD4_XFMO_ICKBB_P XD4_XFMO_CKBB XD4_XFMO_CKB VDD_DIV VDD_DIV pfet_03v3 L=0.28u W=2.5u
M_XD4_XFMO_ICKBB_N XD4_XFMO_CKBB XD4_XFMO_CKB VSS VSS nfet_03v3 L=0.28u W=1u
M_XD4_XFMO_TGMI_P XD4_XFMO_NM XD4_XFMO_CKBB XD4_DMO VDD_DIV pfet_03v3 L=0.28u W=2.5u
M_XD4_XFMO_TGMI_N XD4_DMO XD4_XFMO_CKB XD4_XFMO_NM VSS nfet_03v3 L=0.28u W=1u
M_XD4_XFMO_IA_P XD4_XFMO_NMA XD4_XFMO_NM VDD_DIV VDD_DIV pfet_03v3 L=0.28u W=2.5u
M_XD4_XFMO_IA_N XD4_XFMO_NMA XD4_XFMO_NM VSS VSS nfet_03v3 L=0.28u W=1u
M_XD4_XFMO_IB_P XD4_XFMO_NMB XD4_XFMO_NMA VDD_DIV VDD_DIV pfet_03v3 L=0.28u W=2.5u
M_XD4_XFMO_IB_N XD4_XFMO_NMB XD4_XFMO_NMA VSS VSS nfet_03v3 L=0.28u W=1u
M_XD4_XFMO_TGMF_P XD4_XFMO_NM XD4_XFMO_CKB XD4_XFMO_NMB VDD_DIV pfet_03v3 L=0.28u W=2.5u
M_XD4_XFMO_TGMF_N XD4_XFMO_NMB XD4_XFMO_CKBB XD4_XFMO_NM VSS nfet_03v3 L=0.28u W=1u
M_XD4_XFMO_TGSI_P XD4_XFMO_NS XD4_XFMO_CKB XD4_XFMO_NMA VDD_DIV pfet_03v3 L=0.28u W=2.5u
M_XD4_XFMO_TGSI_N XD4_XFMO_NMA XD4_XFMO_CKBB XD4_XFMO_NS VSS nfet_03v3 L=0.28u W=1u
M_XD4_XFMO_IC_P MO4 XD4_XFMO_NS VDD_DIV VDD_DIV pfet_03v3 L=0.28u W=2.5u
M_XD4_XFMO_IC_N MO4 XD4_XFMO_NS VSS VSS nfet_03v3 L=0.28u W=1u
M_XD4_XFMO_ID_P XD4_MOB MO4 VDD_DIV VDD_DIV pfet_03v3 L=0.28u W=2.5u
M_XD4_XFMO_ID_N XD4_MOB MO4 VSS VSS nfet_03v3 L=0.28u W=1u
M_XD4_XFMO_TGSF_P XD4_XFMO_NS XD4_XFMO_CKBB XD4_MOB VDD_DIV pfet_03v3 L=0.28u W=2.5u
M_XD4_XFMO_TGSF_N XD4_MOB XD4_XFMO_CKB XD4_XFMO_NS VSS nfet_03v3 L=0.28u W=1u
M_XD5_XN3_MPA XD5_SB SEL5 VDD_DIV VDD_DIV pfet_03v3 L=0.28u W=2.5u
M_XD5_XN3_MPB XD5_SB P5 VDD_DIV VDD_DIV pfet_03v3 L=0.28u W=2.5u
M_XD5_XN3_MPC XD5_SB MO5 VDD_DIV VDD_DIV pfet_03v3 L=0.28u W=2.5u
M_XD5_XN3_MNA XD5_SB SEL5 XD5_XN3_NM1 VSS nfet_03v3 L=0.28u W=3u
M_XD5_XN3_MNB XD5_XN3_NM1 P5 XD5_XN3_NM2 VSS nfet_03v3 L=0.28u W=3u
M_XD5_XN3_MNC XD5_XN3_NM2 MO5 VSS VSS nfet_03v3 L=0.28u W=3u
M_XD5_XN2Q_MPA XD5_DQN XD5_QB VDD_DIV VDD_DIV pfet_03v3 L=0.28u W=2.5u
M_XD5_XN2Q_MPB XD5_DQN XD5_SB VDD_DIV VDD_DIV pfet_03v3 L=0.28u W=2.5u
M_XD5_XN2Q_MNA XD5_DQN XD5_QB XD5_XN2Q_NMID VSS nfet_03v3 L=0.28u W=2u
M_XD5_XN2Q_MNB XD5_XN2Q_NMID XD5_SB VSS VSS nfet_03v3 L=0.28u W=2u
M_XD5_XIQ_MP XD5_DQ XD5_DQN VDD_DIV VDD_DIV pfet_03v3 L=0.28u W=2.5u
M_XD5_XIQ_MN XD5_DQ XD5_DQN VSS VSS nfet_03v3 L=0.28u W=1u
M_XD5_XFQ_ICKB_P XD5_XFQ_CKB CK5 VDD_DIV VDD_DIV pfet_03v3 L=0.28u W=2.5u
M_XD5_XFQ_ICKB_N XD5_XFQ_CKB CK5 VSS VSS nfet_03v3 L=0.28u W=1u
M_XD5_XFQ_ICKBB_P XD5_XFQ_CKBB XD5_XFQ_CKB VDD_DIV VDD_DIV pfet_03v3 L=0.28u W=2.5u
M_XD5_XFQ_ICKBB_N XD5_XFQ_CKBB XD5_XFQ_CKB VSS VSS nfet_03v3 L=0.28u W=1u
M_XD5_XFQ_TGMI_P XD5_XFQ_NM XD5_XFQ_CKBB XD5_DQ VDD_DIV pfet_03v3 L=0.28u W=2.5u
M_XD5_XFQ_TGMI_N XD5_DQ XD5_XFQ_CKB XD5_XFQ_NM VSS nfet_03v3 L=0.28u W=1u
M_XD5_XFQ_IA_P XD5_XFQ_NMA XD5_XFQ_NM VDD_DIV VDD_DIV pfet_03v3 L=0.28u W=2.5u
M_XD5_XFQ_IA_N XD5_XFQ_NMA XD5_XFQ_NM VSS VSS nfet_03v3 L=0.28u W=1u
M_XD5_XFQ_IB_P XD5_XFQ_NMB XD5_XFQ_NMA VDD_DIV VDD_DIV pfet_03v3 L=0.28u W=2.5u
M_XD5_XFQ_IB_N XD5_XFQ_NMB XD5_XFQ_NMA VSS VSS nfet_03v3 L=0.28u W=1u
M_XD5_XFQ_TGMF_P XD5_XFQ_NM XD5_XFQ_CKB XD5_XFQ_NMB VDD_DIV pfet_03v3 L=0.28u W=2.5u
M_XD5_XFQ_TGMF_N XD5_XFQ_NMB XD5_XFQ_CKBB XD5_XFQ_NM VSS nfet_03v3 L=0.28u W=1u
M_XD5_XFQ_TGSI_P XD5_XFQ_NS XD5_XFQ_CKB XD5_XFQ_NMA VDD_DIV pfet_03v3 L=0.28u W=2.5u
M_XD5_XFQ_TGSI_N XD5_XFQ_NMA XD5_XFQ_CKBB XD5_XFQ_NS VSS nfet_03v3 L=0.28u W=1u
M_XD5_XFQ_IC_P XD5_Q XD5_XFQ_NS VDD_DIV VDD_DIV pfet_03v3 L=0.28u W=2.5u
M_XD5_XFQ_IC_N XD5_Q XD5_XFQ_NS VSS VSS nfet_03v3 L=0.28u W=1u
M_XD5_XFQ_ID_P XD5_QB XD5_Q VDD_DIV VDD_DIV pfet_03v3 L=0.28u W=2.5u
M_XD5_XFQ_ID_N XD5_QB XD5_Q VSS VSS nfet_03v3 L=0.28u W=1u
M_XD5_XFQ_TGSF_P XD5_XFQ_NS XD5_XFQ_CKBB XD5_QB VDD_DIV pfet_03v3 L=0.28u W=2.5u
M_XD5_XFQ_TGSF_N XD5_QB XD5_XFQ_CKB XD5_XFQ_NS VSS nfet_03v3 L=0.28u W=1u
M_XD5_XICKO_MP CK6 XD5_QB VDD_DIV VDD_DIV pfet_03v3 L=0.28u W=5u
M_XD5_XICKO_MN CK6 XD5_QB VSS VSS nfet_03v3 L=0.28u W=2u
M_XD5_XN2M_MPA XD5_NMO SEL5 VDD_DIV VDD_DIV pfet_03v3 L=0.28u W=2.5u
M_XD5_XN2M_MPB XD5_NMO XD5_Q VDD_DIV VDD_DIV pfet_03v3 L=0.28u W=2.5u
M_XD5_XN2M_MNA XD5_NMO SEL5 XD5_XN2M_NMID VSS nfet_03v3 L=0.28u W=2u
M_XD5_XN2M_MNB XD5_XN2M_NMID XD5_Q VSS VSS nfet_03v3 L=0.28u W=2u
M_XD5_XIM_MP XD5_DMO XD5_NMO VDD_DIV VDD_DIV pfet_03v3 L=0.28u W=2.5u
M_XD5_XIM_MN XD5_DMO XD5_NMO VSS VSS nfet_03v3 L=0.28u W=1u
M_XD5_XFMO_ICKB_P XD5_XFMO_CKB CK5 VDD_DIV VDD_DIV pfet_03v3 L=0.28u W=2.5u
M_XD5_XFMO_ICKB_N XD5_XFMO_CKB CK5 VSS VSS nfet_03v3 L=0.28u W=1u
M_XD5_XFMO_ICKBB_P XD5_XFMO_CKBB XD5_XFMO_CKB VDD_DIV VDD_DIV pfet_03v3 L=0.28u W=2.5u
M_XD5_XFMO_ICKBB_N XD5_XFMO_CKBB XD5_XFMO_CKB VSS VSS nfet_03v3 L=0.28u W=1u
M_XD5_XFMO_TGMI_P XD5_XFMO_NM XD5_XFMO_CKBB XD5_DMO VDD_DIV pfet_03v3 L=0.28u W=2.5u
M_XD5_XFMO_TGMI_N XD5_DMO XD5_XFMO_CKB XD5_XFMO_NM VSS nfet_03v3 L=0.28u W=1u
M_XD5_XFMO_IA_P XD5_XFMO_NMA XD5_XFMO_NM VDD_DIV VDD_DIV pfet_03v3 L=0.28u W=2.5u
M_XD5_XFMO_IA_N XD5_XFMO_NMA XD5_XFMO_NM VSS VSS nfet_03v3 L=0.28u W=1u
M_XD5_XFMO_IB_P XD5_XFMO_NMB XD5_XFMO_NMA VDD_DIV VDD_DIV pfet_03v3 L=0.28u W=2.5u
M_XD5_XFMO_IB_N XD5_XFMO_NMB XD5_XFMO_NMA VSS VSS nfet_03v3 L=0.28u W=1u
M_XD5_XFMO_TGMF_P XD5_XFMO_NM XD5_XFMO_CKB XD5_XFMO_NMB VDD_DIV pfet_03v3 L=0.28u W=2.5u
M_XD5_XFMO_TGMF_N XD5_XFMO_NMB XD5_XFMO_CKBB XD5_XFMO_NM VSS nfet_03v3 L=0.28u W=1u
M_XD5_XFMO_TGSI_P XD5_XFMO_NS XD5_XFMO_CKB XD5_XFMO_NMA VDD_DIV pfet_03v3 L=0.28u W=2.5u
M_XD5_XFMO_TGSI_N XD5_XFMO_NMA XD5_XFMO_CKBB XD5_XFMO_NS VSS nfet_03v3 L=0.28u W=1u
M_XD5_XFMO_IC_P MO5 XD5_XFMO_NS VDD_DIV VDD_DIV pfet_03v3 L=0.28u W=2.5u
M_XD5_XFMO_IC_N MO5 XD5_XFMO_NS VSS VSS nfet_03v3 L=0.28u W=1u
M_XD5_XFMO_ID_P XD5_MOB MO5 VDD_DIV VDD_DIV pfet_03v3 L=0.28u W=2.5u
M_XD5_XFMO_ID_N XD5_MOB MO5 VSS VSS nfet_03v3 L=0.28u W=1u
M_XD5_XFMO_TGSF_P XD5_XFMO_NS XD5_XFMO_CKBB XD5_MOB VDD_DIV pfet_03v3 L=0.28u W=2.5u
M_XD5_XFMO_TGSF_N XD5_MOB XD5_XFMO_CKB XD5_XFMO_NS VSS nfet_03v3 L=0.28u W=1u
M_XNR0_MPA XNR0_PMID MO1 VDD_DIV VDD_DIV pfet_03v3 W=5u L=0.28u
M_XNR0_MPB NMI0 SEL0 XNR0_PMID VDD_DIV pfet_03v3 W=5u L=0.28u
M_XNR0_MNA NMI0 MO1 VSS VSS nfet_03v3 W=1u L=0.28u
M_XNR0_MNB NMI0 SEL0 VSS VSS nfet_03v3 W=1u L=0.28u
M_XIV0_MP MI0 NMI0 VDD_DIV VDD_DIV pfet_03v3 W=2.5u L=0.28u
M_XIV0_MN MI0 NMI0 VSS VSS nfet_03v3 W=1u L=0.28u
M_XNR1_MPA XNR1_PMID MO2 VDD_DIV VDD_DIV pfet_03v3 W=5u L=0.28u
M_XNR1_MPB NMI1 SEL1 XNR1_PMID VDD_DIV pfet_03v3 W=5u L=0.28u
M_XNR1_MNA NMI1 MO2 VSS VSS nfet_03v3 W=1u L=0.28u
M_XNR1_MNB NMI1 SEL1 VSS VSS nfet_03v3 W=1u L=0.28u
M_XIV1_MP MI1 NMI1 VDD_DIV VDD_DIV pfet_03v3 W=2.5u L=0.28u
M_XIV1_MN MI1 NMI1 VSS VSS nfet_03v3 W=1u L=0.28u
M_XNR2_MPA XNR2_PMID MO3 VDD_DIV VDD_DIV pfet_03v3 W=5u L=0.28u
M_XNR2_MPB NMI2 SEL2 XNR2_PMID VDD_DIV pfet_03v3 W=5u L=0.28u
M_XNR2_MNA NMI2 MO3 VSS VSS nfet_03v3 W=1u L=0.28u
M_XNR2_MNB NMI2 SEL2 VSS VSS nfet_03v3 W=1u L=0.28u
M_XIV2_MP MI2 NMI2 VDD_DIV VDD_DIV pfet_03v3 W=2.5u L=0.28u
M_XIV2_MN MI2 NMI2 VSS VSS nfet_03v3 W=1u L=0.28u
M_XNR3_MPA XNR3_PMID MO4 VDD_DIV VDD_DIV pfet_03v3 W=5u L=0.28u
M_XNR3_MPB NMI3 SEL3 XNR3_PMID VDD_DIV pfet_03v3 W=5u L=0.28u
M_XNR3_MNA NMI3 MO4 VSS VSS nfet_03v3 W=1u L=0.28u
M_XNR3_MNB NMI3 SEL3 VSS VSS nfet_03v3 W=1u L=0.28u
M_XIV3_MP MI3 NMI3 VDD_DIV VDD_DIV pfet_03v3 W=2.5u L=0.28u
M_XIV3_MN MI3 NMI3 VSS VSS nfet_03v3 W=1u L=0.28u
M_XNR4_MPA XNR4_PMID MO5 VDD_DIV VDD_DIV pfet_03v3 W=5u L=0.28u
M_XNR4_MPB NMI4 SEL4 XNR4_PMID VDD_DIV pfet_03v3 W=5u L=0.28u
M_XNR4_MNA NMI4 MO5 VSS VSS nfet_03v3 W=1u L=0.28u
M_XNR4_MNB NMI4 SEL4 VSS VSS nfet_03v3 W=1u L=0.28u
M_XIV4_MP MI4 NMI4 VDD_DIV VDD_DIV pfet_03v3 W=2.5u L=0.28u
M_XIV4_MN MI4 NMI4 VSS VSS nfet_03v3 W=1u L=0.28u
M_XM0_MPA T0 CK1 VDD_DIV VDD_DIV pfet_03v3 W=2.5u L=0.28u
M_XM0_MPB T0 SEL0 VDD_DIV VDD_DIV pfet_03v3 W=2.5u L=0.28u
M_XM0_MNA T0 CK1 XM0_NMID VSS nfet_03v3 W=2u L=0.28u
M_XM0_MNB XM0_NMID SEL0 VSS VSS nfet_03v3 W=2u L=0.28u
M_XM1_MPA T1 CK2 VDD_DIV VDD_DIV pfet_03v3 W=2.5u L=0.28u
M_XM1_MPB T1 SEL1 VDD_DIV VDD_DIV pfet_03v3 W=2.5u L=0.28u
M_XM1_MNA T1 CK2 XM1_NMID VSS nfet_03v3 W=2u L=0.28u
M_XM1_MNB XM1_NMID SEL1 VSS VSS nfet_03v3 W=2u L=0.28u
M_XM2_MPA T2 CK3 VDD_DIV VDD_DIV pfet_03v3 W=2.5u L=0.28u
M_XM2_MPB T2 SEL2 VDD_DIV VDD_DIV pfet_03v3 W=2.5u L=0.28u
M_XM2_MNA T2 CK3 XM2_NMID VSS nfet_03v3 W=2u L=0.28u
M_XM2_MNB XM2_NMID SEL2 VSS VSS nfet_03v3 W=2u L=0.28u
M_XM3_MPA T3 CK4 VDD_DIV VDD_DIV pfet_03v3 W=2.5u L=0.28u
M_XM3_MPB T3 SEL3 VDD_DIV VDD_DIV pfet_03v3 W=2.5u L=0.28u
M_XM3_MNA T3 CK4 XM3_NMID VSS nfet_03v3 W=2u L=0.28u
M_XM3_MNB XM3_NMID SEL3 VSS VSS nfet_03v3 W=2u L=0.28u
M_XM4_MPA T4 CK5 VDD_DIV VDD_DIV pfet_03v3 W=2.5u L=0.28u
M_XM4_MPB T4 SEL4 VDD_DIV VDD_DIV pfet_03v3 W=2.5u L=0.28u
M_XM4_MNA T4 CK5 XM4_NMID VSS nfet_03v3 W=2u L=0.28u
M_XM4_MNB XM4_NMID SEL4 VSS VSS nfet_03v3 W=2u L=0.28u
M_XM5_MPA T5 CK6 VDD_DIV VDD_DIV pfet_03v3 W=2.5u L=0.28u
M_XM5_MPB T5 SEL5 VDD_DIV VDD_DIV pfet_03v3 W=2.5u L=0.28u
M_XM5_MNA T5 CK6 XM5_NMID VSS nfet_03v3 W=2u L=0.28u
M_XM5_MNB XM5_NMID SEL5 VSS VSS nfet_03v3 W=2u L=0.28u
M_XMA_MPA MA T0 VDD_DIV VDD_DIV pfet_03v3 W=2.5u L=0.28u
M_XMA_MPB MA T1 VDD_DIV VDD_DIV pfet_03v3 W=2.5u L=0.28u
M_XMA_MPC MA T2 VDD_DIV VDD_DIV pfet_03v3 W=2.5u L=0.28u
M_XMA_MNA MA T0 XMA_NM1 VSS nfet_03v3 W=3u L=0.28u
M_XMA_MNB XMA_NM1 T1 XMA_NM2 VSS nfet_03v3 W=3u L=0.28u
M_XMA_MNC XMA_NM2 T2 VSS VSS nfet_03v3 W=3u L=0.28u
M_XMB_MPA MB T3 VDD_DIV VDD_DIV pfet_03v3 W=2.5u L=0.28u
M_XMB_MPB MB T4 VDD_DIV VDD_DIV pfet_03v3 W=2.5u L=0.28u
M_XMB_MPC MB T5 VDD_DIV VDD_DIV pfet_03v3 W=2.5u L=0.28u
M_XMB_MNA MB T3 XMB_NM1 VSS nfet_03v3 W=3u L=0.28u
M_XMB_MNB XMB_NM1 T4 XMB_NM2 VSS nfet_03v3 W=3u L=0.28u
M_XMB_MNC XMB_NM2 T5 VSS VSS nfet_03v3 W=3u L=0.28u
M_XMNO_MPA XMNO_PMID MA VDD_DIV VDD_DIV pfet_03v3 W=5u L=0.28u
M_XMNO_MPB DIVOUTB MB XMNO_PMID VDD_DIV pfet_03v3 W=5u L=0.28u
M_XMNO_MNA DIVOUTB MA VSS VSS nfet_03v3 W=1u L=0.28u
M_XMNO_MNB DIVOUTB MB VSS VSS nfet_03v3 W=1u L=0.28u
M_XIDO_MP DIVOUT DIVOUTB VDD_DIV VDD_DIV pfet_03v3 W=5u L=0.28u
M_XIDO_MN DIVOUT DIVOUTB VSS VSS nfet_03v3 W=2u L=0.28u
M_XFRT_ICKB_P XFRT_CKB VCO VDD_DIV VDD_DIV pfet_03v3 W=2.5u L=0.28u
M_XFRT_ICKB_N XFRT_CKB VCO VSS VSS nfet_03v3 W=1u L=0.28u
M_XFRT_ICKBB_P XFRT_CKBB XFRT_CKB VDD_DIV VDD_DIV pfet_03v3 W=2.5u L=0.28u
M_XFRT_ICKBB_N XFRT_CKBB XFRT_CKB VSS VSS nfet_03v3 W=1u L=0.28u
M_XFRT_TGMI_P XFRT_NM XFRT_CKBB DIVOUT VDD_DIV pfet_03v3 W=2.5u L=0.28u
M_XFRT_TGMI_N DIVOUT XFRT_CKB XFRT_NM VSS nfet_03v3 W=1u L=0.28u
M_XFRT_IA_P XFRT_NMA XFRT_NM VDD_DIV VDD_DIV pfet_03v3 W=2.5u L=0.28u
M_XFRT_IA_N XFRT_NMA XFRT_NM VSS VSS nfet_03v3 W=1u L=0.28u
M_XFRT_IB_P XFRT_NMB XFRT_NMA VDD_DIV VDD_DIV pfet_03v3 W=2.5u L=0.28u
M_XFRT_IB_N XFRT_NMB XFRT_NMA VSS VSS nfet_03v3 W=1u L=0.28u
M_XFRT_TGMF_P XFRT_NM XFRT_CKB XFRT_NMB VDD_DIV pfet_03v3 W=2.5u L=0.28u
M_XFRT_TGMF_N XFRT_NMB XFRT_CKBB XFRT_NM VSS nfet_03v3 W=1u L=0.28u
M_XFRT_TGSI_P XFRT_NS XFRT_CKB XFRT_NMA VDD_DIV pfet_03v3 W=2.5u L=0.28u
M_XFRT_TGSI_N XFRT_NMA XFRT_CKBB XFRT_NS VSS nfet_03v3 W=1u L=0.28u
M_XFRT_IC_P FB XFRT_NS VDD_DIV VDD_DIV pfet_03v3 W=2.5u L=0.28u
M_XFRT_IC_N FB XFRT_NS VSS VSS nfet_03v3 W=1u L=0.28u
M_XFRT_ID_P FBB FB VDD_DIV VDD_DIV pfet_03v3 W=2.5u L=0.28u
M_XFRT_ID_N FBB FB VSS VSS nfet_03v3 W=1u L=0.28u
M_XFRT_TGSF_P XFRT_NS XFRT_CKBB FBB VDD_DIV pfet_03v3 W=2.5u L=0.28u
M_XFRT_TGSF_N FBB XFRT_CKB XFRT_NS VSS nfet_03v3 W=1u L=0.28u
.ends
