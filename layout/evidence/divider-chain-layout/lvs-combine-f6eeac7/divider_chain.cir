* Extracted by KLayout with GF180MCU LVS runset on : 17/11/2026 00:52

.SUBCKT divider_chain
M$1 XMNO_PMID MB DIVOUTB VDD_DIV pfet_03v3 L=0.28U W=5U AS=2.5P AD=2.5P PS=11U
+ PD=11U
M$2 VDD_DIV DIVOUTB DIVOUT VDD_DIV pfet_03v3 L=0.28U W=5U AS=2.5P AD=2.5P
+ PS=11U PD=11U
M$3 VDD_DIV MI0 \$103 VDD_DIV pfet_03v3 L=0.28U W=2.5U AS=1.25P AD=1.25P PS=6U
+ PD=6U
M$4 VDD_DIV P0 \$103 VDD_DIV pfet_03v3 L=0.28U W=2.5U AS=1.25P AD=1.25P PS=6U
+ PD=6U
M$5 VDD_DIV MO0 \$103 VDD_DIV pfet_03v3 L=0.28U W=2.5U AS=1.25P AD=1.25P PS=6U
+ PD=6U
M$6 VDD_DIV \$28 \$29 VDD_DIV pfet_03v3 L=0.28U W=2.5U AS=1.25P AD=1.25P PS=6U
+ PD=6U
M$7 VDD_DIV \$103 \$29 VDD_DIV pfet_03v3 L=0.28U W=2.5U AS=1.25P AD=1.25P PS=6U
+ PD=6U
M$8 VDD_DIV \$29 \$31 VDD_DIV pfet_03v3 L=0.28U W=2.5U AS=1.25P AD=1.25P PS=6U
+ PD=6U
M$9 VDD_DIV VCO \$32 VDD_DIV pfet_03v3 L=0.28U W=2.5U AS=1.25P AD=1.25P PS=6U
+ PD=6U
M$10 VDD_DIV \$32 \$33 VDD_DIV pfet_03v3 L=0.28U W=2.5U AS=1.25P AD=1.25P PS=6U
+ PD=6U
M$11 \$31 \$33 \$34 VDD_DIV pfet_03v3 L=0.28U W=2.5U AS=1.25P AD=1.25P PS=6U
+ PD=6U
M$12 VDD_DIV \$34 \$35 VDD_DIV pfet_03v3 L=0.28U W=2.5U AS=1.25P AD=1.25P PS=6U
+ PD=6U
M$13 VDD_DIV \$35 \$107 VDD_DIV pfet_03v3 L=0.28U W=2.5U AS=1.25P AD=1.25P
+ PS=6U PD=6U
M$14 \$107 \$32 \$34 VDD_DIV pfet_03v3 L=0.28U W=2.5U AS=1.25P AD=1.25P PS=6U
+ PD=6U
M$15 \$35 \$32 \$36 VDD_DIV pfet_03v3 L=0.28U W=2.5U AS=1.25P AD=1.25P PS=6U
+ PD=6U
M$16 VDD_DIV \$36 \$37 VDD_DIV pfet_03v3 L=0.28U W=2.5U AS=1.25P AD=1.25P PS=6U
+ PD=6U
M$17 VDD_DIV \$37 \$28 VDD_DIV pfet_03v3 L=0.28U W=2.5U AS=1.25P AD=1.25P PS=6U
+ PD=6U
M$18 \$28 \$33 \$36 VDD_DIV pfet_03v3 L=0.28U W=2.5U AS=1.25P AD=1.25P PS=6U
+ PD=6U
M$19 VDD_DIV \$28 CK1 VDD_DIV pfet_03v3 L=0.28U W=5U AS=2.5P AD=2.5P PS=11U
+ PD=11U
M$20 VDD_DIV MI0 \$39 VDD_DIV pfet_03v3 L=0.28U W=2.5U AS=1.25P AD=1.25P PS=6U
+ PD=6U
M$21 VDD_DIV \$37 \$39 VDD_DIV pfet_03v3 L=0.28U W=2.5U AS=1.25P AD=1.25P PS=6U
+ PD=6U
M$22 VDD_DIV \$39 \$40 VDD_DIV pfet_03v3 L=0.28U W=2.5U AS=1.25P AD=1.25P PS=6U
+ PD=6U
M$23 VDD_DIV VCO \$41 VDD_DIV pfet_03v3 L=0.28U W=2.5U AS=1.25P AD=1.25P PS=6U
+ PD=6U
M$24 VDD_DIV \$41 \$42 VDD_DIV pfet_03v3 L=0.28U W=2.5U AS=1.25P AD=1.25P PS=6U
+ PD=6U
M$25 \$40 \$42 \$43 VDD_DIV pfet_03v3 L=0.28U W=2.5U AS=1.25P AD=1.25P PS=6U
+ PD=6U
M$26 VDD_DIV \$43 \$44 VDD_DIV pfet_03v3 L=0.28U W=2.5U AS=1.25P AD=1.25P PS=6U
+ PD=6U
M$27 VDD_DIV \$44 \$45 VDD_DIV pfet_03v3 L=0.28U W=2.5U AS=1.25P AD=1.25P PS=6U
+ PD=6U
M$28 \$45 \$41 \$43 VDD_DIV pfet_03v3 L=0.28U W=2.5U AS=1.25P AD=1.25P PS=6U
+ PD=6U
M$29 \$44 \$41 \$46 VDD_DIV pfet_03v3 L=0.28U W=2.5U AS=1.25P AD=1.25P PS=6U
+ PD=6U
M$30 VDD_DIV \$46 MO0 VDD_DIV pfet_03v3 L=0.28U W=2.5U AS=1.25P AD=1.25P PS=6U
+ PD=6U
M$31 VDD_DIV MO0 \$47 VDD_DIV pfet_03v3 L=0.28U W=2.5U AS=1.25P AD=1.25P PS=6U
+ PD=6U
M$32 \$47 \$42 \$46 VDD_DIV pfet_03v3 L=0.28U W=2.5U AS=1.25P AD=1.25P PS=6U
+ PD=6U
M$33 XNR0_PMID SEL0 NMI0 VDD_DIV pfet_03v3 L=0.28U W=5U AS=2.5P AD=2.5P PS=11U
+ PD=11U
M$34 VDD_DIV NMI0 MI0 VDD_DIV pfet_03v3 L=0.28U W=2.5U AS=1.25P AD=1.25P PS=6U
+ PD=6U
M$35 VDD_DIV CK1 T0 VDD_DIV pfet_03v3 L=0.28U W=2.5U AS=1.25P AD=1.25P PS=6U
+ PD=6U
M$36 VDD_DIV SEL0 T0 VDD_DIV pfet_03v3 L=0.28U W=2.5U AS=1.25P AD=1.25P PS=6U
+ PD=6U
M$37 VDD_DIV MI1 \$104 VDD_DIV pfet_03v3 L=0.28U W=2.5U AS=1.25P AD=1.25P PS=6U
+ PD=6U
M$38 VDD_DIV P1 \$104 VDD_DIV pfet_03v3 L=0.28U W=2.5U AS=1.25P AD=1.25P PS=6U
+ PD=6U
M$39 VDD_DIV MO1 \$104 VDD_DIV pfet_03v3 L=0.28U W=2.5U AS=1.25P AD=1.25P PS=6U
+ PD=6U
M$40 VDD_DIV \$51 \$52 VDD_DIV pfet_03v3 L=0.28U W=2.5U AS=1.25P AD=1.25P PS=6U
+ PD=6U
M$41 VDD_DIV \$104 \$52 VDD_DIV pfet_03v3 L=0.28U W=2.5U AS=1.25P AD=1.25P
+ PS=6U PD=6U
M$42 VDD_DIV \$52 \$54 VDD_DIV pfet_03v3 L=0.28U W=2.5U AS=1.25P AD=1.25P PS=6U
+ PD=6U
M$43 VDD_DIV CK1 \$55 VDD_DIV pfet_03v3 L=0.28U W=2.5U AS=1.25P AD=1.25P PS=6U
+ PD=6U
M$44 VDD_DIV \$55 \$56 VDD_DIV pfet_03v3 L=0.28U W=2.5U AS=1.25P AD=1.25P PS=6U
+ PD=6U
M$45 \$54 \$56 \$57 VDD_DIV pfet_03v3 L=0.28U W=2.5U AS=1.25P AD=1.25P PS=6U
+ PD=6U
M$46 VDD_DIV \$57 \$58 VDD_DIV pfet_03v3 L=0.28U W=2.5U AS=1.25P AD=1.25P PS=6U
+ PD=6U
M$47 VDD_DIV \$58 \$59 VDD_DIV pfet_03v3 L=0.28U W=2.5U AS=1.25P AD=1.25P PS=6U
+ PD=6U
M$48 \$59 \$55 \$57 VDD_DIV pfet_03v3 L=0.28U W=2.5U AS=1.25P AD=1.25P PS=6U
+ PD=6U
M$49 \$58 \$55 \$60 VDD_DIV pfet_03v3 L=0.28U W=2.5U AS=1.25P AD=1.25P PS=6U
+ PD=6U
M$50 VDD_DIV \$60 \$61 VDD_DIV pfet_03v3 L=0.28U W=2.5U AS=1.25P AD=1.25P PS=6U
+ PD=6U
M$51 VDD_DIV \$61 \$51 VDD_DIV pfet_03v3 L=0.28U W=2.5U AS=1.25P AD=1.25P PS=6U
+ PD=6U
M$52 \$51 \$56 \$60 VDD_DIV pfet_03v3 L=0.28U W=2.5U AS=1.25P AD=1.25P PS=6U
+ PD=6U
M$53 VDD_DIV \$51 CK2 VDD_DIV pfet_03v3 L=0.28U W=5U AS=2.5P AD=2.5P PS=11U
+ PD=11U
M$54 VDD_DIV MI1 \$64 VDD_DIV pfet_03v3 L=0.28U W=2.5U AS=1.25P AD=1.25P PS=6U
+ PD=6U
M$55 VDD_DIV \$61 \$64 VDD_DIV pfet_03v3 L=0.28U W=2.5U AS=1.25P AD=1.25P PS=6U
+ PD=6U
M$56 VDD_DIV \$64 \$65 VDD_DIV pfet_03v3 L=0.28U W=2.5U AS=1.25P AD=1.25P PS=6U
+ PD=6U
M$57 VDD_DIV CK1 \$66 VDD_DIV pfet_03v3 L=0.28U W=2.5U AS=1.25P AD=1.25P PS=6U
+ PD=6U
M$58 VDD_DIV \$66 \$67 VDD_DIV pfet_03v3 L=0.28U W=2.5U AS=1.25P AD=1.25P PS=6U
+ PD=6U
M$59 \$65 \$67 \$68 VDD_DIV pfet_03v3 L=0.28U W=2.5U AS=1.25P AD=1.25P PS=6U
+ PD=6U
M$60 VDD_DIV \$68 \$69 VDD_DIV pfet_03v3 L=0.28U W=2.5U AS=1.25P AD=1.25P PS=6U
+ PD=6U
M$61 VDD_DIV \$69 \$70 VDD_DIV pfet_03v3 L=0.28U W=2.5U AS=1.25P AD=1.25P PS=6U
+ PD=6U
M$62 \$70 \$66 \$68 VDD_DIV pfet_03v3 L=0.28U W=2.5U AS=1.25P AD=1.25P PS=6U
+ PD=6U
M$63 \$69 \$66 \$71 VDD_DIV pfet_03v3 L=0.28U W=2.5U AS=1.25P AD=1.25P PS=6U
+ PD=6U
M$64 VDD_DIV \$71 MO1 VDD_DIV pfet_03v3 L=0.28U W=2.5U AS=1.25P AD=1.25P PS=6U
+ PD=6U
M$65 VDD_DIV MO1 \$72 VDD_DIV pfet_03v3 L=0.28U W=2.5U AS=1.25P AD=1.25P PS=6U
+ PD=6U
M$66 \$72 \$67 \$71 VDD_DIV pfet_03v3 L=0.28U W=2.5U AS=1.25P AD=1.25P PS=6U
+ PD=6U
M$67 XNR1_PMID SEL1 NMI1 VDD_DIV pfet_03v3 L=0.28U W=5U AS=2.5P AD=2.5P PS=11U
+ PD=11U
M$68 VDD_DIV NMI1 MI1 VDD_DIV pfet_03v3 L=0.28U W=2.5U AS=1.25P AD=1.25P PS=6U
+ PD=6U
M$69 VDD_DIV CK2 T1 VDD_DIV pfet_03v3 L=0.28U W=2.5U AS=1.25P AD=1.25P PS=6U
+ PD=6U
M$70 VDD_DIV SEL1 T1 VDD_DIV pfet_03v3 L=0.28U W=2.5U AS=1.25P AD=1.25P PS=6U
+ PD=6U
M$71 VDD_DIV MI2 \$105 VDD_DIV pfet_03v3 L=0.28U W=2.5U AS=1.25P AD=1.25P PS=6U
+ PD=6U
M$72 VDD_DIV P2 \$105 VDD_DIV pfet_03v3 L=0.28U W=2.5U AS=1.25P AD=1.25P PS=6U
+ PD=6U
M$73 VDD_DIV MO2 \$105 VDD_DIV pfet_03v3 L=0.28U W=2.5U AS=1.25P AD=1.25P PS=6U
+ PD=6U
M$74 VDD_DIV \$76 \$77 VDD_DIV pfet_03v3 L=0.28U W=2.5U AS=1.25P AD=1.25P PS=6U
+ PD=6U
M$75 VDD_DIV \$105 \$77 VDD_DIV pfet_03v3 L=0.28U W=2.5U AS=1.25P AD=1.25P
+ PS=6U PD=6U
M$76 VDD_DIV \$77 \$79 VDD_DIV pfet_03v3 L=0.28U W=2.5U AS=1.25P AD=1.25P PS=6U
+ PD=6U
M$77 VDD_DIV CK2 \$80 VDD_DIV pfet_03v3 L=0.28U W=2.5U AS=1.25P AD=1.25P PS=6U
+ PD=6U
M$78 VDD_DIV \$80 \$81 VDD_DIV pfet_03v3 L=0.28U W=2.5U AS=1.25P AD=1.25P PS=6U
+ PD=6U
M$79 \$79 \$81 \$82 VDD_DIV pfet_03v3 L=0.28U W=2.5U AS=1.25P AD=1.25P PS=6U
+ PD=6U
M$80 VDD_DIV \$82 \$83 VDD_DIV pfet_03v3 L=0.28U W=2.5U AS=1.25P AD=1.25P PS=6U
+ PD=6U
M$81 VDD_DIV \$83 \$84 VDD_DIV pfet_03v3 L=0.28U W=2.5U AS=1.25P AD=1.25P PS=6U
+ PD=6U
M$82 \$84 \$80 \$82 VDD_DIV pfet_03v3 L=0.28U W=2.5U AS=1.25P AD=1.25P PS=6U
+ PD=6U
M$83 \$83 \$80 \$85 VDD_DIV pfet_03v3 L=0.28U W=2.5U AS=1.25P AD=1.25P PS=6U
+ PD=6U
M$84 VDD_DIV \$85 \$86 VDD_DIV pfet_03v3 L=0.28U W=2.5U AS=1.25P AD=1.25P PS=6U
+ PD=6U
M$85 VDD_DIV \$86 \$76 VDD_DIV pfet_03v3 L=0.28U W=2.5U AS=1.25P AD=1.25P PS=6U
+ PD=6U
M$86 \$76 \$81 \$85 VDD_DIV pfet_03v3 L=0.28U W=2.5U AS=1.25P AD=1.25P PS=6U
+ PD=6U
M$87 VDD_DIV \$76 CK3 VDD_DIV pfet_03v3 L=0.28U W=5U AS=2.5P AD=2.5P PS=11U
+ PD=11U
M$88 VDD_DIV MI2 \$87 VDD_DIV pfet_03v3 L=0.28U W=2.5U AS=1.25P AD=1.25P PS=6U
+ PD=6U
M$89 VDD_DIV \$86 \$87 VDD_DIV pfet_03v3 L=0.28U W=2.5U AS=1.25P AD=1.25P PS=6U
+ PD=6U
M$90 VDD_DIV \$87 \$89 VDD_DIV pfet_03v3 L=0.28U W=2.5U AS=1.25P AD=1.25P PS=6U
+ PD=6U
M$91 VDD_DIV CK2 \$90 VDD_DIV pfet_03v3 L=0.28U W=2.5U AS=1.25P AD=1.25P PS=6U
+ PD=6U
M$92 VDD_DIV \$90 \$91 VDD_DIV pfet_03v3 L=0.28U W=2.5U AS=1.25P AD=1.25P PS=6U
+ PD=6U
M$93 \$89 \$91 \$92 VDD_DIV pfet_03v3 L=0.28U W=2.5U AS=1.25P AD=1.25P PS=6U
+ PD=6U
M$94 VDD_DIV \$92 \$93 VDD_DIV pfet_03v3 L=0.28U W=2.5U AS=1.25P AD=1.25P PS=6U
+ PD=6U
M$95 VDD_DIV \$93 \$94 VDD_DIV pfet_03v3 L=0.28U W=2.5U AS=1.25P AD=1.25P PS=6U
+ PD=6U
M$96 \$94 \$90 \$92 VDD_DIV pfet_03v3 L=0.28U W=2.5U AS=1.25P AD=1.25P PS=6U
+ PD=6U
M$97 \$93 \$90 \$95 VDD_DIV pfet_03v3 L=0.28U W=2.5U AS=1.25P AD=1.25P PS=6U
+ PD=6U
M$98 VDD_DIV \$95 MO2 VDD_DIV pfet_03v3 L=0.28U W=2.5U AS=1.25P AD=1.25P PS=6U
+ PD=6U
M$99 VDD_DIV MO2 \$96 VDD_DIV pfet_03v3 L=0.28U W=2.5U AS=1.25P AD=1.25P PS=6U
+ PD=6U
M$100 \$96 \$91 \$95 VDD_DIV pfet_03v3 L=0.28U W=2.5U AS=1.25P AD=1.25P PS=6U
+ PD=6U
M$101 XNR2_PMID SEL2 NMI2 VDD_DIV pfet_03v3 L=0.28U W=5U AS=2.5P AD=2.5P PS=11U
+ PD=11U
M$102 VDD_DIV NMI2 MI2 VDD_DIV pfet_03v3 L=0.28U W=2.5U AS=1.25P AD=1.25P PS=6U
+ PD=6U
M$103 VDD_DIV CK3 T2 VDD_DIV pfet_03v3 L=0.28U W=2.5U AS=1.25P AD=1.25P PS=6U
+ PD=6U
M$104 VDD_DIV SEL2 T2 VDD_DIV pfet_03v3 L=0.28U W=2.5U AS=1.25P AD=1.25P PS=6U
+ PD=6U
M$105 VDD_DIV T0 MA VDD_DIV pfet_03v3 L=0.28U W=2.5U AS=1.25P AD=1.25P PS=6U
+ PD=6U
M$106 VDD_DIV T1 MA VDD_DIV pfet_03v3 L=0.28U W=2.5U AS=1.25P AD=1.25P PS=6U
+ PD=6U
M$107 VDD_DIV T2 MA VDD_DIV pfet_03v3 L=0.28U W=2.5U AS=1.25P AD=1.25P PS=6U
+ PD=6U
M$108 VDD_DIV MA XMNO_PMID VDD_DIV pfet_03v3 L=0.28U W=5U AS=2.5P AD=2.5P
+ PS=11U PD=11U
M$109 VDD_DIV MO1 XNR0_PMID VDD_DIV pfet_03v3 L=0.28U W=5U AS=2.5P AD=2.5P
+ PS=11U PD=11U
M$110 VDD_DIV MO2 XNR1_PMID VDD_DIV pfet_03v3 L=0.28U W=5U AS=2.5P AD=2.5P
+ PS=11U PD=11U
M$111 VDD_DIV MO3 XNR2_PMID VDD_DIV pfet_03v3 L=0.28U W=5U AS=2.5P AD=2.5P
+ PS=11U PD=11U
M$112 VDD_DIV VCO XFRT_CKB VDD_DIV pfet_03v3 L=0.28U W=2.5U AS=1.25P AD=1.25P
+ PS=6U PD=6U
M$113 VDD_DIV XFRT_CKB XFRT_CKBB VDD_DIV pfet_03v3 L=0.28U W=2.5U AS=1.25P
+ AD=1.25P PS=6U PD=6U
M$114 DIVOUT XFRT_CKBB XFRT_NM VDD_DIV pfet_03v3 L=0.28U W=2.5U AS=1.25P
+ AD=1.25P PS=6U PD=6U
M$115 VDD_DIV XFRT_NM XFRT_NMA VDD_DIV pfet_03v3 L=0.28U W=2.5U AS=1.25P
+ AD=1.25P PS=6U PD=6U
M$116 VDD_DIV XFRT_NMA XFRT_NMB VDD_DIV pfet_03v3 L=0.28U W=2.5U AS=1.25P
+ AD=1.25P PS=6U PD=6U
M$117 XFRT_NMB XFRT_CKB XFRT_NM VDD_DIV pfet_03v3 L=0.28U W=2.5U AS=1.25P
+ AD=1.25P PS=6U PD=6U
M$118 XFRT_NMA XFRT_CKB XFRT_NS VDD_DIV pfet_03v3 L=0.28U W=2.5U AS=1.25P
+ AD=1.25P PS=6U PD=6U
M$119 VDD_DIV XFRT_NS FB VDD_DIV pfet_03v3 L=0.28U W=2.5U AS=1.25P AD=1.25P
+ PS=6U PD=6U
M$120 VDD_DIV FB FBB VDD_DIV pfet_03v3 L=0.28U W=2.5U AS=1.25P AD=1.25P PS=6U
+ PD=6U
M$121 FBB XFRT_CKBB XFRT_NS VDD_DIV pfet_03v3 L=0.28U W=2.5U AS=1.25P AD=1.25P
+ PS=6U PD=6U
M$122 VDD_DIV MI3 \$213 VDD_DIV pfet_03v3 L=0.28U W=2.5U AS=1.25P AD=1.25P
+ PS=6U PD=6U
M$123 VDD_DIV P3 \$213 VDD_DIV pfet_03v3 L=0.28U W=2.5U AS=1.25P AD=1.25P PS=6U
+ PD=6U
M$124 VDD_DIV MO3 \$213 VDD_DIV pfet_03v3 L=0.28U W=2.5U AS=1.25P AD=1.25P
+ PS=6U PD=6U
M$125 VDD_DIV \$196 \$197 VDD_DIV pfet_03v3 L=0.28U W=2.5U AS=1.25P AD=1.25P
+ PS=6U PD=6U
M$126 VDD_DIV \$213 \$197 VDD_DIV pfet_03v3 L=0.28U W=2.5U AS=1.25P AD=1.25P
+ PS=6U PD=6U
M$127 VDD_DIV \$197 \$133 VDD_DIV pfet_03v3 L=0.28U W=2.5U AS=1.25P AD=1.25P
+ PS=6U PD=6U
M$128 VDD_DIV CK3 \$134 VDD_DIV pfet_03v3 L=0.28U W=2.5U AS=1.25P AD=1.25P
+ PS=6U PD=6U
M$129 VDD_DIV \$134 \$135 VDD_DIV pfet_03v3 L=0.28U W=2.5U AS=1.25P AD=1.25P
+ PS=6U PD=6U
M$130 \$133 \$135 \$136 VDD_DIV pfet_03v3 L=0.28U W=2.5U AS=1.25P AD=1.25P
+ PS=6U PD=6U
M$131 VDD_DIV \$136 \$137 VDD_DIV pfet_03v3 L=0.28U W=2.5U AS=1.25P AD=1.25P
+ PS=6U PD=6U
M$132 VDD_DIV \$137 \$138 VDD_DIV pfet_03v3 L=0.28U W=2.5U AS=1.25P AD=1.25P
+ PS=6U PD=6U
M$133 \$138 \$134 \$136 VDD_DIV pfet_03v3 L=0.28U W=2.5U AS=1.25P AD=1.25P
+ PS=6U PD=6U
M$134 \$137 \$134 \$139 VDD_DIV pfet_03v3 L=0.28U W=2.5U AS=1.25P AD=1.25P
+ PS=6U PD=6U
M$135 VDD_DIV \$139 \$140 VDD_DIV pfet_03v3 L=0.28U W=2.5U AS=1.25P AD=1.25P
+ PS=6U PD=6U
M$136 VDD_DIV \$140 \$196 VDD_DIV pfet_03v3 L=0.28U W=2.5U AS=1.25P AD=1.25P
+ PS=6U PD=6U
M$137 \$196 \$135 \$139 VDD_DIV pfet_03v3 L=0.28U W=2.5U AS=1.25P AD=1.25P
+ PS=6U PD=6U
M$138 VDD_DIV \$196 CK4 VDD_DIV pfet_03v3 L=0.28U W=5U AS=2.5P AD=2.5P PS=11U
+ PD=11U
M$139 VDD_DIV MI3 \$198 VDD_DIV pfet_03v3 L=0.28U W=2.5U AS=1.25P AD=1.25P
+ PS=6U PD=6U
M$140 VDD_DIV \$140 \$198 VDD_DIV pfet_03v3 L=0.28U W=2.5U AS=1.25P AD=1.25P
+ PS=6U PD=6U
M$141 VDD_DIV \$198 \$142 VDD_DIV pfet_03v3 L=0.28U W=2.5U AS=1.25P AD=1.25P
+ PS=6U PD=6U
M$142 VDD_DIV CK3 \$143 VDD_DIV pfet_03v3 L=0.28U W=2.5U AS=1.25P AD=1.25P
+ PS=6U PD=6U
M$143 VDD_DIV \$143 \$144 VDD_DIV pfet_03v3 L=0.28U W=2.5U AS=1.25P AD=1.25P
+ PS=6U PD=6U
M$144 \$142 \$144 \$145 VDD_DIV pfet_03v3 L=0.28U W=2.5U AS=1.25P AD=1.25P
+ PS=6U PD=6U
M$145 VDD_DIV \$145 \$146 VDD_DIV pfet_03v3 L=0.28U W=2.5U AS=1.25P AD=1.25P
+ PS=6U PD=6U
M$146 VDD_DIV \$146 \$147 VDD_DIV pfet_03v3 L=0.28U W=2.5U AS=1.25P AD=1.25P
+ PS=6U PD=6U
M$147 \$147 \$143 \$145 VDD_DIV pfet_03v3 L=0.28U W=2.5U AS=1.25P AD=1.25P
+ PS=6U PD=6U
M$148 \$146 \$143 \$148 VDD_DIV pfet_03v3 L=0.28U W=2.5U AS=1.25P AD=1.25P
+ PS=6U PD=6U
M$149 VDD_DIV \$148 MO3 VDD_DIV pfet_03v3 L=0.28U W=2.5U AS=1.25P AD=1.25P
+ PS=6U PD=6U
M$150 VDD_DIV MO3 \$149 VDD_DIV pfet_03v3 L=0.28U W=2.5U AS=1.25P AD=1.25P
+ PS=6U PD=6U
M$151 \$149 \$144 \$148 VDD_DIV pfet_03v3 L=0.28U W=2.5U AS=1.25P AD=1.25P
+ PS=6U PD=6U
M$152 XNR3_PMID SEL3 NMI3 VDD_DIV pfet_03v3 L=0.28U W=5U AS=2.5P AD=2.5P PS=11U
+ PD=11U
M$153 VDD_DIV NMI3 MI3 VDD_DIV pfet_03v3 L=0.28U W=2.5U AS=1.25P AD=1.25P PS=6U
+ PD=6U
M$154 VDD_DIV CK4 T3 VDD_DIV pfet_03v3 L=0.28U W=2.5U AS=1.25P AD=1.25P PS=6U
+ PD=6U
M$155 VDD_DIV SEL3 T3 VDD_DIV pfet_03v3 L=0.28U W=2.5U AS=1.25P AD=1.25P PS=6U
+ PD=6U
M$156 VDD_DIV MI4 \$214 VDD_DIV pfet_03v3 L=0.28U W=2.5U AS=1.25P AD=1.25P
+ PS=6U PD=6U
M$157 VDD_DIV P4 \$214 VDD_DIV pfet_03v3 L=0.28U W=2.5U AS=1.25P AD=1.25P PS=6U
+ PD=6U
M$158 VDD_DIV MO4 \$214 VDD_DIV pfet_03v3 L=0.28U W=2.5U AS=1.25P AD=1.25P
+ PS=6U PD=6U
M$159 VDD_DIV \$202 \$203 VDD_DIV pfet_03v3 L=0.28U W=2.5U AS=1.25P AD=1.25P
+ PS=6U PD=6U
M$160 VDD_DIV \$214 \$203 VDD_DIV pfet_03v3 L=0.28U W=2.5U AS=1.25P AD=1.25P
+ PS=6U PD=6U
M$161 VDD_DIV \$203 \$155 VDD_DIV pfet_03v3 L=0.28U W=2.5U AS=1.25P AD=1.25P
+ PS=6U PD=6U
M$162 VDD_DIV CK4 \$156 VDD_DIV pfet_03v3 L=0.28U W=2.5U AS=1.25P AD=1.25P
+ PS=6U PD=6U
M$163 VDD_DIV \$156 \$157 VDD_DIV pfet_03v3 L=0.28U W=2.5U AS=1.25P AD=1.25P
+ PS=6U PD=6U
M$164 \$155 \$157 \$158 VDD_DIV pfet_03v3 L=0.28U W=2.5U AS=1.25P AD=1.25P
+ PS=6U PD=6U
M$165 VDD_DIV \$158 \$159 VDD_DIV pfet_03v3 L=0.28U W=2.5U AS=1.25P AD=1.25P
+ PS=6U PD=6U
M$166 VDD_DIV \$159 \$160 VDD_DIV pfet_03v3 L=0.28U W=2.5U AS=1.25P AD=1.25P
+ PS=6U PD=6U
M$167 \$160 \$156 \$158 VDD_DIV pfet_03v3 L=0.28U W=2.5U AS=1.25P AD=1.25P
+ PS=6U PD=6U
M$168 \$159 \$156 \$161 VDD_DIV pfet_03v3 L=0.28U W=2.5U AS=1.25P AD=1.25P
+ PS=6U PD=6U
M$169 VDD_DIV \$161 \$162 VDD_DIV pfet_03v3 L=0.28U W=2.5U AS=1.25P AD=1.25P
+ PS=6U PD=6U
M$170 VDD_DIV \$162 \$202 VDD_DIV pfet_03v3 L=0.28U W=2.5U AS=1.25P AD=1.25P
+ PS=6U PD=6U
M$171 \$202 \$157 \$161 VDD_DIV pfet_03v3 L=0.28U W=2.5U AS=1.25P AD=1.25P
+ PS=6U PD=6U
M$172 VDD_DIV \$202 CK5 VDD_DIV pfet_03v3 L=0.28U W=5U AS=2.5P AD=2.5P PS=11U
+ PD=11U
M$173 VDD_DIV MI4 \$204 VDD_DIV pfet_03v3 L=0.28U W=2.5U AS=1.25P AD=1.25P
+ PS=6U PD=6U
M$174 VDD_DIV \$162 \$204 VDD_DIV pfet_03v3 L=0.28U W=2.5U AS=1.25P AD=1.25P
+ PS=6U PD=6U
M$175 VDD_DIV \$204 \$164 VDD_DIV pfet_03v3 L=0.28U W=2.5U AS=1.25P AD=1.25P
+ PS=6U PD=6U
M$176 VDD_DIV CK4 \$165 VDD_DIV pfet_03v3 L=0.28U W=2.5U AS=1.25P AD=1.25P
+ PS=6U PD=6U
M$177 VDD_DIV \$165 \$166 VDD_DIV pfet_03v3 L=0.28U W=2.5U AS=1.25P AD=1.25P
+ PS=6U PD=6U
M$178 \$164 \$166 \$167 VDD_DIV pfet_03v3 L=0.28U W=2.5U AS=1.25P AD=1.25P
+ PS=6U PD=6U
M$179 VDD_DIV \$167 \$168 VDD_DIV pfet_03v3 L=0.28U W=2.5U AS=1.25P AD=1.25P
+ PS=6U PD=6U
M$180 VDD_DIV \$168 \$169 VDD_DIV pfet_03v3 L=0.28U W=2.5U AS=1.25P AD=1.25P
+ PS=6U PD=6U
M$181 \$169 \$165 \$167 VDD_DIV pfet_03v3 L=0.28U W=2.5U AS=1.25P AD=1.25P
+ PS=6U PD=6U
M$182 \$168 \$165 \$170 VDD_DIV pfet_03v3 L=0.28U W=2.5U AS=1.25P AD=1.25P
+ PS=6U PD=6U
M$183 VDD_DIV \$170 MO4 VDD_DIV pfet_03v3 L=0.28U W=2.5U AS=1.25P AD=1.25P
+ PS=6U PD=6U
M$184 VDD_DIV MO4 \$171 VDD_DIV pfet_03v3 L=0.28U W=2.5U AS=1.25P AD=1.25P
+ PS=6U PD=6U
M$185 \$171 \$166 \$170 VDD_DIV pfet_03v3 L=0.28U W=2.5U AS=1.25P AD=1.25P
+ PS=6U PD=6U
M$186 XNR4_PMID SEL4 NMI4 VDD_DIV pfet_03v3 L=0.28U W=5U AS=2.5P AD=2.5P PS=11U
+ PD=11U
M$187 VDD_DIV NMI4 MI4 VDD_DIV pfet_03v3 L=0.28U W=2.5U AS=1.25P AD=1.25P PS=6U
+ PD=6U
M$188 VDD_DIV CK5 T4 VDD_DIV pfet_03v3 L=0.28U W=2.5U AS=1.25P AD=1.25P PS=6U
+ PD=6U
M$189 VDD_DIV SEL4 T4 VDD_DIV pfet_03v3 L=0.28U W=2.5U AS=1.25P AD=1.25P PS=6U
+ PD=6U
M$190 VDD_DIV SEL5 \$215 VDD_DIV pfet_03v3 L=0.28U W=2.5U AS=1.25P AD=1.25P
+ PS=6U PD=6U
M$191 VDD_DIV P5 \$215 VDD_DIV pfet_03v3 L=0.28U W=2.5U AS=1.25P AD=1.25P PS=6U
+ PD=6U
M$192 VDD_DIV MO5 \$215 VDD_DIV pfet_03v3 L=0.28U W=2.5U AS=1.25P AD=1.25P
+ PS=6U PD=6U
M$193 VDD_DIV \$208 \$209 VDD_DIV pfet_03v3 L=0.28U W=2.5U AS=1.25P AD=1.25P
+ PS=6U PD=6U
M$194 VDD_DIV \$215 \$209 VDD_DIV pfet_03v3 L=0.28U W=2.5U AS=1.25P AD=1.25P
+ PS=6U PD=6U
M$195 VDD_DIV \$209 \$176 VDD_DIV pfet_03v3 L=0.28U W=2.5U AS=1.25P AD=1.25P
+ PS=6U PD=6U
M$196 VDD_DIV CK5 \$177 VDD_DIV pfet_03v3 L=0.28U W=2.5U AS=1.25P AD=1.25P
+ PS=6U PD=6U
M$197 VDD_DIV \$177 \$178 VDD_DIV pfet_03v3 L=0.28U W=2.5U AS=1.25P AD=1.25P
+ PS=6U PD=6U
M$198 \$176 \$178 \$179 VDD_DIV pfet_03v3 L=0.28U W=2.5U AS=1.25P AD=1.25P
+ PS=6U PD=6U
M$199 VDD_DIV \$179 \$180 VDD_DIV pfet_03v3 L=0.28U W=2.5U AS=1.25P AD=1.25P
+ PS=6U PD=6U
M$200 VDD_DIV \$180 \$181 VDD_DIV pfet_03v3 L=0.28U W=2.5U AS=1.25P AD=1.25P
+ PS=6U PD=6U
M$201 \$181 \$177 \$179 VDD_DIV pfet_03v3 L=0.28U W=2.5U AS=1.25P AD=1.25P
+ PS=6U PD=6U
M$202 \$180 \$177 \$182 VDD_DIV pfet_03v3 L=0.28U W=2.5U AS=1.25P AD=1.25P
+ PS=6U PD=6U
M$203 VDD_DIV \$182 \$183 VDD_DIV pfet_03v3 L=0.28U W=2.5U AS=1.25P AD=1.25P
+ PS=6U PD=6U
M$204 VDD_DIV \$183 \$208 VDD_DIV pfet_03v3 L=0.28U W=2.5U AS=1.25P AD=1.25P
+ PS=6U PD=6U
M$205 \$208 \$178 \$182 VDD_DIV pfet_03v3 L=0.28U W=2.5U AS=1.25P AD=1.25P
+ PS=6U PD=6U
M$206 VDD_DIV \$208 CK6 VDD_DIV pfet_03v3 L=0.28U W=5U AS=2.5P AD=2.5P PS=11U
+ PD=11U
M$207 VDD_DIV SEL5 \$210 VDD_DIV pfet_03v3 L=0.28U W=2.5U AS=1.25P AD=1.25P
+ PS=6U PD=6U
M$208 VDD_DIV \$183 \$210 VDD_DIV pfet_03v3 L=0.28U W=2.5U AS=1.25P AD=1.25P
+ PS=6U PD=6U
M$209 VDD_DIV \$210 \$185 VDD_DIV pfet_03v3 L=0.28U W=2.5U AS=1.25P AD=1.25P
+ PS=6U PD=6U
M$210 VDD_DIV CK5 \$186 VDD_DIV pfet_03v3 L=0.28U W=2.5U AS=1.25P AD=1.25P
+ PS=6U PD=6U
M$211 VDD_DIV \$186 \$187 VDD_DIV pfet_03v3 L=0.28U W=2.5U AS=1.25P AD=1.25P
+ PS=6U PD=6U
M$212 \$185 \$187 \$188 VDD_DIV pfet_03v3 L=0.28U W=2.5U AS=1.25P AD=1.25P
+ PS=6U PD=6U
M$213 VDD_DIV \$188 \$189 VDD_DIV pfet_03v3 L=0.28U W=2.5U AS=1.25P AD=1.25P
+ PS=6U PD=6U
M$214 VDD_DIV \$189 \$190 VDD_DIV pfet_03v3 L=0.28U W=2.5U AS=1.25P AD=1.25P
+ PS=6U PD=6U
M$215 \$190 \$186 \$188 VDD_DIV pfet_03v3 L=0.28U W=2.5U AS=1.25P AD=1.25P
+ PS=6U PD=6U
M$216 \$189 \$186 \$191 VDD_DIV pfet_03v3 L=0.28U W=2.5U AS=1.25P AD=1.25P
+ PS=6U PD=6U
M$217 VDD_DIV \$191 MO5 VDD_DIV pfet_03v3 L=0.28U W=2.5U AS=1.25P AD=1.25P
+ PS=6U PD=6U
M$218 VDD_DIV MO5 \$192 VDD_DIV pfet_03v3 L=0.28U W=2.5U AS=1.25P AD=1.25P
+ PS=6U PD=6U
M$219 \$192 \$187 \$191 VDD_DIV pfet_03v3 L=0.28U W=2.5U AS=1.25P AD=1.25P
+ PS=6U PD=6U
M$220 VDD_DIV CK6 T5 VDD_DIV pfet_03v3 L=0.28U W=2.5U AS=1.25P AD=1.25P PS=6U
+ PD=6U
M$221 VDD_DIV SEL5 T5 VDD_DIV pfet_03v3 L=0.28U W=2.5U AS=1.25P AD=1.25P PS=6U
+ PD=6U
M$222 VDD_DIV T3 MB VDD_DIV pfet_03v3 L=0.28U W=2.5U AS=1.25P AD=1.25P PS=6U
+ PD=6U
M$223 VDD_DIV T4 MB VDD_DIV pfet_03v3 L=0.28U W=2.5U AS=1.25P AD=1.25P PS=6U
+ PD=6U
M$224 VDD_DIV T5 MB VDD_DIV pfet_03v3 L=0.28U W=2.5U AS=1.25P AD=1.25P PS=6U
+ PD=6U
M$225 VDD_DIV MO4 XNR3_PMID VDD_DIV pfet_03v3 L=0.28U W=5U AS=2.5P AD=2.5P
+ PS=11U PD=11U
M$226 VDD_DIV MO5 XNR4_PMID VDD_DIV pfet_03v3 L=0.28U W=5U AS=2.5P AD=2.5P
+ PS=11U PD=11U
M$227 DIVOUTB MA VSS VSS nfet_03v3 L=0.28U W=1U AS=0.5P AD=0.5P PS=3U PD=3U
M$228 DIVOUTB MB VSS VSS nfet_03v3 L=0.28U W=1U AS=0.5P AD=0.5P PS=3U PD=3U
M$229 DIVOUT DIVOUTB VSS VSS nfet_03v3 L=0.28U W=2U AS=1P AD=1P PS=5U PD=5U
M$230 \$27 MO0 VSS VSS nfet_03v3 L=0.28U W=3U AS=1.5P AD=1.5P PS=7U PD=7U
M$231 \$30 \$103 VSS VSS nfet_03v3 L=0.28U W=2U AS=1P AD=1P PS=5U PD=5U
M$232 \$31 \$29 VSS VSS nfet_03v3 L=0.28U W=1U AS=0.5P AD=0.5P PS=3U PD=3U
M$233 \$32 VCO VSS VSS nfet_03v3 L=0.28U W=1U AS=0.5P AD=0.5P PS=3U PD=3U
M$234 \$33 \$32 VSS VSS nfet_03v3 L=0.28U W=1U AS=0.5P AD=0.5P PS=3U PD=3U
M$235 \$34 \$32 \$31 VSS nfet_03v3 L=0.28U W=1U AS=0.5P AD=0.5P PS=3U PD=3U
M$236 \$35 \$34 VSS VSS nfet_03v3 L=0.28U W=1U AS=0.5P AD=0.5P PS=3U PD=3U
M$237 \$107 \$35 VSS VSS nfet_03v3 L=0.28U W=1U AS=0.5P AD=0.5P PS=3U PD=3U
M$238 \$34 \$33 \$107 VSS nfet_03v3 L=0.28U W=1U AS=0.5P AD=0.5P PS=3U PD=3U
M$239 \$36 \$33 \$35 VSS nfet_03v3 L=0.28U W=1U AS=0.5P AD=0.5P PS=3U PD=3U
M$240 \$37 \$36 VSS VSS nfet_03v3 L=0.28U W=1U AS=0.5P AD=0.5P PS=3U PD=3U
M$241 \$28 \$37 VSS VSS nfet_03v3 L=0.28U W=1U AS=0.5P AD=0.5P PS=3U PD=3U
M$242 \$36 \$32 \$28 VSS nfet_03v3 L=0.28U W=1U AS=0.5P AD=0.5P PS=3U PD=3U
M$243 CK1 \$28 VSS VSS nfet_03v3 L=0.28U W=2U AS=1P AD=1P PS=5U PD=5U
M$244 \$38 \$37 VSS VSS nfet_03v3 L=0.28U W=2U AS=1P AD=1P PS=5U PD=5U
M$245 \$40 \$39 VSS VSS nfet_03v3 L=0.28U W=1U AS=0.5P AD=0.5P PS=3U PD=3U
M$246 \$41 VCO VSS VSS nfet_03v3 L=0.28U W=1U AS=0.5P AD=0.5P PS=3U PD=3U
M$247 \$42 \$41 VSS VSS nfet_03v3 L=0.28U W=1U AS=0.5P AD=0.5P PS=3U PD=3U
M$248 \$43 \$41 \$40 VSS nfet_03v3 L=0.28U W=1U AS=0.5P AD=0.5P PS=3U PD=3U
M$249 \$44 \$43 VSS VSS nfet_03v3 L=0.28U W=1U AS=0.5P AD=0.5P PS=3U PD=3U
M$250 \$45 \$44 VSS VSS nfet_03v3 L=0.28U W=1U AS=0.5P AD=0.5P PS=3U PD=3U
M$251 \$43 \$42 \$45 VSS nfet_03v3 L=0.28U W=1U AS=0.5P AD=0.5P PS=3U PD=3U
M$252 \$46 \$42 \$44 VSS nfet_03v3 L=0.28U W=1U AS=0.5P AD=0.5P PS=3U PD=3U
M$253 MO0 \$46 VSS VSS nfet_03v3 L=0.28U W=1U AS=0.5P AD=0.5P PS=3U PD=3U
M$254 \$47 MO0 VSS VSS nfet_03v3 L=0.28U W=1U AS=0.5P AD=0.5P PS=3U PD=3U
M$255 \$46 \$41 \$47 VSS nfet_03v3 L=0.28U W=1U AS=0.5P AD=0.5P PS=3U PD=3U
M$256 NMI0 MO1 VSS VSS nfet_03v3 L=0.28U W=1U AS=0.5P AD=0.5P PS=3U PD=3U
M$257 NMI0 SEL0 VSS VSS nfet_03v3 L=0.28U W=1U AS=0.5P AD=0.5P PS=3U PD=3U
M$258 MI0 NMI0 VSS VSS nfet_03v3 L=0.28U W=1U AS=0.5P AD=0.5P PS=3U PD=3U
M$259 XM0_NMID SEL0 VSS VSS nfet_03v3 L=0.28U W=2U AS=1P AD=1P PS=5U PD=5U
M$260 \$50 MO1 VSS VSS nfet_03v3 L=0.28U W=3U AS=1.5P AD=1.5P PS=7U PD=7U
M$261 \$53 \$104 VSS VSS nfet_03v3 L=0.28U W=2U AS=1P AD=1P PS=5U PD=5U
M$262 \$54 \$52 VSS VSS nfet_03v3 L=0.28U W=1U AS=0.5P AD=0.5P PS=3U PD=3U
M$263 \$55 CK1 VSS VSS nfet_03v3 L=0.28U W=1U AS=0.5P AD=0.5P PS=3U PD=3U
M$264 \$56 \$55 VSS VSS nfet_03v3 L=0.28U W=1U AS=0.5P AD=0.5P PS=3U PD=3U
M$265 \$57 \$55 \$54 VSS nfet_03v3 L=0.28U W=1U AS=0.5P AD=0.5P PS=3U PD=3U
M$266 \$58 \$57 VSS VSS nfet_03v3 L=0.28U W=1U AS=0.5P AD=0.5P PS=3U PD=3U
M$267 \$59 \$58 VSS VSS nfet_03v3 L=0.28U W=1U AS=0.5P AD=0.5P PS=3U PD=3U
M$268 \$57 \$56 \$59 VSS nfet_03v3 L=0.28U W=1U AS=0.5P AD=0.5P PS=3U PD=3U
M$269 \$60 \$56 \$58 VSS nfet_03v3 L=0.28U W=1U AS=0.5P AD=0.5P PS=3U PD=3U
M$270 \$61 \$60 VSS VSS nfet_03v3 L=0.28U W=1U AS=0.5P AD=0.5P PS=3U PD=3U
M$271 \$51 \$61 VSS VSS nfet_03v3 L=0.28U W=1U AS=0.5P AD=0.5P PS=3U PD=3U
M$272 \$60 \$55 \$51 VSS nfet_03v3 L=0.28U W=1U AS=0.5P AD=0.5P PS=3U PD=3U
M$273 CK2 \$51 VSS VSS nfet_03v3 L=0.28U W=2U AS=1P AD=1P PS=5U PD=5U
M$274 \$63 \$61 VSS VSS nfet_03v3 L=0.28U W=2U AS=1P AD=1P PS=5U PD=5U
M$275 \$65 \$64 VSS VSS nfet_03v3 L=0.28U W=1U AS=0.5P AD=0.5P PS=3U PD=3U
M$276 \$66 CK1 VSS VSS nfet_03v3 L=0.28U W=1U AS=0.5P AD=0.5P PS=3U PD=3U
M$277 \$67 \$66 VSS VSS nfet_03v3 L=0.28U W=1U AS=0.5P AD=0.5P PS=3U PD=3U
M$278 \$68 \$66 \$65 VSS nfet_03v3 L=0.28U W=1U AS=0.5P AD=0.5P PS=3U PD=3U
M$279 \$69 \$68 VSS VSS nfet_03v3 L=0.28U W=1U AS=0.5P AD=0.5P PS=3U PD=3U
M$280 \$70 \$69 VSS VSS nfet_03v3 L=0.28U W=1U AS=0.5P AD=0.5P PS=3U PD=3U
M$281 \$68 \$67 \$70 VSS nfet_03v3 L=0.28U W=1U AS=0.5P AD=0.5P PS=3U PD=3U
M$282 \$71 \$67 \$69 VSS nfet_03v3 L=0.28U W=1U AS=0.5P AD=0.5P PS=3U PD=3U
M$283 MO1 \$71 VSS VSS nfet_03v3 L=0.28U W=1U AS=0.5P AD=0.5P PS=3U PD=3U
M$284 \$72 MO1 VSS VSS nfet_03v3 L=0.28U W=1U AS=0.5P AD=0.5P PS=3U PD=3U
M$285 \$71 \$66 \$72 VSS nfet_03v3 L=0.28U W=1U AS=0.5P AD=0.5P PS=3U PD=3U
M$286 NMI1 MO2 VSS VSS nfet_03v3 L=0.28U W=1U AS=0.5P AD=0.5P PS=3U PD=3U
M$287 NMI1 SEL1 VSS VSS nfet_03v3 L=0.28U W=1U AS=0.5P AD=0.5P PS=3U PD=3U
M$288 MI1 NMI1 VSS VSS nfet_03v3 L=0.28U W=1U AS=0.5P AD=0.5P PS=3U PD=3U
M$289 XM1_NMID SEL1 VSS VSS nfet_03v3 L=0.28U W=2U AS=1P AD=1P PS=5U PD=5U
M$290 \$74 MO2 VSS VSS nfet_03v3 L=0.28U W=3U AS=1.5P AD=1.5P PS=7U PD=7U
M$291 \$78 \$105 VSS VSS nfet_03v3 L=0.28U W=2U AS=1P AD=1P PS=5U PD=5U
M$292 \$79 \$77 VSS VSS nfet_03v3 L=0.28U W=1U AS=0.5P AD=0.5P PS=3U PD=3U
M$293 \$80 CK2 VSS VSS nfet_03v3 L=0.28U W=1U AS=0.5P AD=0.5P PS=3U PD=3U
M$294 \$81 \$80 VSS VSS nfet_03v3 L=0.28U W=1U AS=0.5P AD=0.5P PS=3U PD=3U
M$295 \$82 \$80 \$79 VSS nfet_03v3 L=0.28U W=1U AS=0.5P AD=0.5P PS=3U PD=3U
M$296 \$83 \$82 VSS VSS nfet_03v3 L=0.28U W=1U AS=0.5P AD=0.5P PS=3U PD=3U
M$297 \$84 \$83 VSS VSS nfet_03v3 L=0.28U W=1U AS=0.5P AD=0.5P PS=3U PD=3U
M$298 \$82 \$81 \$84 VSS nfet_03v3 L=0.28U W=1U AS=0.5P AD=0.5P PS=3U PD=3U
M$299 \$85 \$81 \$83 VSS nfet_03v3 L=0.28U W=1U AS=0.5P AD=0.5P PS=3U PD=3U
M$300 \$86 \$85 VSS VSS nfet_03v3 L=0.28U W=1U AS=0.5P AD=0.5P PS=3U PD=3U
M$301 \$76 \$86 VSS VSS nfet_03v3 L=0.28U W=1U AS=0.5P AD=0.5P PS=3U PD=3U
M$302 \$85 \$80 \$76 VSS nfet_03v3 L=0.28U W=1U AS=0.5P AD=0.5P PS=3U PD=3U
M$303 CK3 \$76 VSS VSS nfet_03v3 L=0.28U W=2U AS=1P AD=1P PS=5U PD=5U
M$304 \$88 \$86 VSS VSS nfet_03v3 L=0.28U W=2U AS=1P AD=1P PS=5U PD=5U
M$305 \$89 \$87 VSS VSS nfet_03v3 L=0.28U W=1U AS=0.5P AD=0.5P PS=3U PD=3U
M$306 \$90 CK2 VSS VSS nfet_03v3 L=0.28U W=1U AS=0.5P AD=0.5P PS=3U PD=3U
M$307 \$91 \$90 VSS VSS nfet_03v3 L=0.28U W=1U AS=0.5P AD=0.5P PS=3U PD=3U
M$308 \$92 \$90 \$89 VSS nfet_03v3 L=0.28U W=1U AS=0.5P AD=0.5P PS=3U PD=3U
M$309 \$93 \$92 VSS VSS nfet_03v3 L=0.28U W=1U AS=0.5P AD=0.5P PS=3U PD=3U
M$310 \$94 \$93 VSS VSS nfet_03v3 L=0.28U W=1U AS=0.5P AD=0.5P PS=3U PD=3U
M$311 \$92 \$91 \$94 VSS nfet_03v3 L=0.28U W=1U AS=0.5P AD=0.5P PS=3U PD=3U
M$312 \$95 \$91 \$93 VSS nfet_03v3 L=0.28U W=1U AS=0.5P AD=0.5P PS=3U PD=3U
M$313 MO2 \$95 VSS VSS nfet_03v3 L=0.28U W=1U AS=0.5P AD=0.5P PS=3U PD=3U
M$314 \$96 MO2 VSS VSS nfet_03v3 L=0.28U W=1U AS=0.5P AD=0.5P PS=3U PD=3U
M$315 \$95 \$90 \$96 VSS nfet_03v3 L=0.28U W=1U AS=0.5P AD=0.5P PS=3U PD=3U
M$316 NMI2 MO3 VSS VSS nfet_03v3 L=0.28U W=1U AS=0.5P AD=0.5P PS=3U PD=3U
M$317 NMI2 SEL2 VSS VSS nfet_03v3 L=0.28U W=1U AS=0.5P AD=0.5P PS=3U PD=3U
M$318 MI2 NMI2 VSS VSS nfet_03v3 L=0.28U W=1U AS=0.5P AD=0.5P PS=3U PD=3U
M$319 XM2_NMID SEL2 VSS VSS nfet_03v3 L=0.28U W=2U AS=1P AD=1P PS=5U PD=5U
M$320 XMA_NM2 T2 VSS VSS nfet_03v3 L=0.28U W=3U AS=1.5P AD=1.5P PS=7U PD=7U
M$321 \$103 MI0 \$26 VSS nfet_03v3 L=0.28U W=3U AS=1.5P AD=1.5P PS=7U PD=7U
M$322 \$26 P0 \$27 VSS nfet_03v3 L=0.28U W=3U AS=1.5P AD=1.5P PS=7U PD=7U
M$323 \$29 \$28 \$30 VSS nfet_03v3 L=0.28U W=2U AS=1P AD=1P PS=5U PD=5U
M$324 \$39 MI0 \$38 VSS nfet_03v3 L=0.28U W=2U AS=1P AD=1P PS=5U PD=5U
M$325 T0 CK1 XM0_NMID VSS nfet_03v3 L=0.28U W=2U AS=1P AD=1P PS=5U PD=5U
M$326 \$104 MI1 \$49 VSS nfet_03v3 L=0.28U W=3U AS=1.5P AD=1.5P PS=7U PD=7U
M$327 \$49 P1 \$50 VSS nfet_03v3 L=0.28U W=3U AS=1.5P AD=1.5P PS=7U PD=7U
M$328 \$52 \$51 \$53 VSS nfet_03v3 L=0.28U W=2U AS=1P AD=1P PS=5U PD=5U
M$329 \$64 MI1 \$63 VSS nfet_03v3 L=0.28U W=2U AS=1P AD=1P PS=5U PD=5U
M$330 T1 CK2 XM1_NMID VSS nfet_03v3 L=0.28U W=2U AS=1P AD=1P PS=5U PD=5U
M$331 \$75 P2 \$74 VSS nfet_03v3 L=0.28U W=3U AS=1.5P AD=1.5P PS=7U PD=7U
M$332 \$105 MI2 \$75 VSS nfet_03v3 L=0.28U W=3U AS=1.5P AD=1.5P PS=7U PD=7U
M$333 \$77 \$76 \$78 VSS nfet_03v3 L=0.28U W=2U AS=1P AD=1P PS=5U PD=5U
M$334 \$87 MI2 \$88 VSS nfet_03v3 L=0.28U W=2U AS=1P AD=1P PS=5U PD=5U
M$335 T2 CK3 XM2_NMID VSS nfet_03v3 L=0.28U W=2U AS=1P AD=1P PS=5U PD=5U
M$336 MA T0 XMA_NM1 VSS nfet_03v3 L=0.28U W=3U AS=1.5P AD=1.5P PS=7U PD=7U
M$337 XMA_NM1 T1 XMA_NM2 VSS nfet_03v3 L=0.28U W=3U AS=1.5P AD=1.5P PS=7U PD=7U
M$338 XFRT_CKB VCO VSS VSS nfet_03v3 L=0.28U W=1U AS=0.5P AD=0.5P PS=3U PD=3U
M$339 XFRT_CKBB XFRT_CKB VSS VSS nfet_03v3 L=0.28U W=1U AS=0.5P AD=0.5P PS=3U
+ PD=3U
M$340 XFRT_NM XFRT_CKB DIVOUT VSS nfet_03v3 L=0.28U W=1U AS=0.5P AD=0.5P PS=3U
+ PD=3U
M$341 XFRT_NMA XFRT_NM VSS VSS nfet_03v3 L=0.28U W=1U AS=0.5P AD=0.5P PS=3U
+ PD=3U
M$342 XFRT_NMB XFRT_NMA VSS VSS nfet_03v3 L=0.28U W=1U AS=0.5P AD=0.5P PS=3U
+ PD=3U
M$343 XFRT_NM XFRT_CKBB XFRT_NMB VSS nfet_03v3 L=0.28U W=1U AS=0.5P AD=0.5P
+ PS=3U PD=3U
M$344 XFRT_NS XFRT_CKBB XFRT_NMA VSS nfet_03v3 L=0.28U W=1U AS=0.5P AD=0.5P
+ PS=3U PD=3U
M$345 FB XFRT_NS VSS VSS nfet_03v3 L=0.28U W=1U AS=0.5P AD=0.5P PS=3U PD=3U
M$346 FBB FB VSS VSS nfet_03v3 L=0.28U W=1U AS=0.5P AD=0.5P PS=3U PD=3U
M$347 XFRT_NS XFRT_CKB FBB VSS nfet_03v3 L=0.28U W=1U AS=0.5P AD=0.5P PS=3U
+ PD=3U
M$348 \$110 MO3 VSS VSS nfet_03v3 L=0.28U W=3U AS=1.5P AD=1.5P PS=7U PD=7U
M$349 \$132 \$213 VSS VSS nfet_03v3 L=0.28U W=2U AS=1P AD=1P PS=5U PD=5U
M$350 \$133 \$197 VSS VSS nfet_03v3 L=0.28U W=1U AS=0.5P AD=0.5P PS=3U PD=3U
M$351 \$134 CK3 VSS VSS nfet_03v3 L=0.28U W=1U AS=0.5P AD=0.5P PS=3U PD=3U
M$352 \$135 \$134 VSS VSS nfet_03v3 L=0.28U W=1U AS=0.5P AD=0.5P PS=3U PD=3U
M$353 \$136 \$134 \$133 VSS nfet_03v3 L=0.28U W=1U AS=0.5P AD=0.5P PS=3U PD=3U
M$354 \$137 \$136 VSS VSS nfet_03v3 L=0.28U W=1U AS=0.5P AD=0.5P PS=3U PD=3U
M$355 \$138 \$137 VSS VSS nfet_03v3 L=0.28U W=1U AS=0.5P AD=0.5P PS=3U PD=3U
M$356 \$136 \$135 \$138 VSS nfet_03v3 L=0.28U W=1U AS=0.5P AD=0.5P PS=3U PD=3U
M$357 \$139 \$135 \$137 VSS nfet_03v3 L=0.28U W=1U AS=0.5P AD=0.5P PS=3U PD=3U
M$358 \$140 \$139 VSS VSS nfet_03v3 L=0.28U W=1U AS=0.5P AD=0.5P PS=3U PD=3U
M$359 \$196 \$140 VSS VSS nfet_03v3 L=0.28U W=1U AS=0.5P AD=0.5P PS=3U PD=3U
M$360 \$139 \$134 \$196 VSS nfet_03v3 L=0.28U W=1U AS=0.5P AD=0.5P PS=3U PD=3U
M$361 CK4 \$196 VSS VSS nfet_03v3 L=0.28U W=2U AS=1P AD=1P PS=5U PD=5U
M$362 \$141 \$140 VSS VSS nfet_03v3 L=0.28U W=2U AS=1P AD=1P PS=5U PD=5U
M$363 \$142 \$198 VSS VSS nfet_03v3 L=0.28U W=1U AS=0.5P AD=0.5P PS=3U PD=3U
M$364 \$143 CK3 VSS VSS nfet_03v3 L=0.28U W=1U AS=0.5P AD=0.5P PS=3U PD=3U
M$365 \$144 \$143 VSS VSS nfet_03v3 L=0.28U W=1U AS=0.5P AD=0.5P PS=3U PD=3U
M$366 \$145 \$143 \$142 VSS nfet_03v3 L=0.28U W=1U AS=0.5P AD=0.5P PS=3U PD=3U
M$367 \$146 \$145 VSS VSS nfet_03v3 L=0.28U W=1U AS=0.5P AD=0.5P PS=3U PD=3U
M$368 \$147 \$146 VSS VSS nfet_03v3 L=0.28U W=1U AS=0.5P AD=0.5P PS=3U PD=3U
M$369 \$145 \$144 \$147 VSS nfet_03v3 L=0.28U W=1U AS=0.5P AD=0.5P PS=3U PD=3U
M$370 \$148 \$144 \$146 VSS nfet_03v3 L=0.28U W=1U AS=0.5P AD=0.5P PS=3U PD=3U
M$371 MO3 \$148 VSS VSS nfet_03v3 L=0.28U W=1U AS=0.5P AD=0.5P PS=3U PD=3U
M$372 \$149 MO3 VSS VSS nfet_03v3 L=0.28U W=1U AS=0.5P AD=0.5P PS=3U PD=3U
M$373 \$148 \$143 \$149 VSS nfet_03v3 L=0.28U W=1U AS=0.5P AD=0.5P PS=3U PD=3U
M$374 NMI3 MO4 VSS VSS nfet_03v3 L=0.28U W=1U AS=0.5P AD=0.5P PS=3U PD=3U
M$375 NMI3 SEL3 VSS VSS nfet_03v3 L=0.28U W=1U AS=0.5P AD=0.5P PS=3U PD=3U
M$376 MI3 NMI3 VSS VSS nfet_03v3 L=0.28U W=1U AS=0.5P AD=0.5P PS=3U PD=3U
M$377 XM3_NMID SEL3 VSS VSS nfet_03v3 L=0.28U W=2U AS=1P AD=1P PS=5U PD=5U
M$378 \$153 MO4 VSS VSS nfet_03v3 L=0.28U W=3U AS=1.5P AD=1.5P PS=7U PD=7U
M$379 \$154 \$214 VSS VSS nfet_03v3 L=0.28U W=2U AS=1P AD=1P PS=5U PD=5U
M$380 \$155 \$203 VSS VSS nfet_03v3 L=0.28U W=1U AS=0.5P AD=0.5P PS=3U PD=3U
M$381 \$156 CK4 VSS VSS nfet_03v3 L=0.28U W=1U AS=0.5P AD=0.5P PS=3U PD=3U
M$382 \$157 \$156 VSS VSS nfet_03v3 L=0.28U W=1U AS=0.5P AD=0.5P PS=3U PD=3U
M$383 \$158 \$156 \$155 VSS nfet_03v3 L=0.28U W=1U AS=0.5P AD=0.5P PS=3U PD=3U
M$384 \$159 \$158 VSS VSS nfet_03v3 L=0.28U W=1U AS=0.5P AD=0.5P PS=3U PD=3U
M$385 \$160 \$159 VSS VSS nfet_03v3 L=0.28U W=1U AS=0.5P AD=0.5P PS=3U PD=3U
M$386 \$158 \$157 \$160 VSS nfet_03v3 L=0.28U W=1U AS=0.5P AD=0.5P PS=3U PD=3U
M$387 \$161 \$157 \$159 VSS nfet_03v3 L=0.28U W=1U AS=0.5P AD=0.5P PS=3U PD=3U
M$388 \$162 \$161 VSS VSS nfet_03v3 L=0.28U W=1U AS=0.5P AD=0.5P PS=3U PD=3U
M$389 \$202 \$162 VSS VSS nfet_03v3 L=0.28U W=1U AS=0.5P AD=0.5P PS=3U PD=3U
M$390 \$161 \$156 \$202 VSS nfet_03v3 L=0.28U W=1U AS=0.5P AD=0.5P PS=3U PD=3U
M$391 CK5 \$202 VSS VSS nfet_03v3 L=0.28U W=2U AS=1P AD=1P PS=5U PD=5U
M$392 \$163 \$162 VSS VSS nfet_03v3 L=0.28U W=2U AS=1P AD=1P PS=5U PD=5U
M$393 \$164 \$204 VSS VSS nfet_03v3 L=0.28U W=1U AS=0.5P AD=0.5P PS=3U PD=3U
M$394 \$165 CK4 VSS VSS nfet_03v3 L=0.28U W=1U AS=0.5P AD=0.5P PS=3U PD=3U
M$395 \$166 \$165 VSS VSS nfet_03v3 L=0.28U W=1U AS=0.5P AD=0.5P PS=3U PD=3U
M$396 \$167 \$165 \$164 VSS nfet_03v3 L=0.28U W=1U AS=0.5P AD=0.5P PS=3U PD=3U
M$397 \$168 \$167 VSS VSS nfet_03v3 L=0.28U W=1U AS=0.5P AD=0.5P PS=3U PD=3U
M$398 \$169 \$168 VSS VSS nfet_03v3 L=0.28U W=1U AS=0.5P AD=0.5P PS=3U PD=3U
M$399 \$167 \$166 \$169 VSS nfet_03v3 L=0.28U W=1U AS=0.5P AD=0.5P PS=3U PD=3U
M$400 \$170 \$166 \$168 VSS nfet_03v3 L=0.28U W=1U AS=0.5P AD=0.5P PS=3U PD=3U
M$401 MO4 \$170 VSS VSS nfet_03v3 L=0.28U W=1U AS=0.5P AD=0.5P PS=3U PD=3U
M$402 \$171 MO4 VSS VSS nfet_03v3 L=0.28U W=1U AS=0.5P AD=0.5P PS=3U PD=3U
M$403 \$170 \$165 \$171 VSS nfet_03v3 L=0.28U W=1U AS=0.5P AD=0.5P PS=3U PD=3U
M$404 NMI4 MO5 VSS VSS nfet_03v3 L=0.28U W=1U AS=0.5P AD=0.5P PS=3U PD=3U
M$405 NMI4 SEL4 VSS VSS nfet_03v3 L=0.28U W=1U AS=0.5P AD=0.5P PS=3U PD=3U
M$406 MI4 NMI4 VSS VSS nfet_03v3 L=0.28U W=1U AS=0.5P AD=0.5P PS=3U PD=3U
M$407 XM4_NMID SEL4 VSS VSS nfet_03v3 L=0.28U W=2U AS=1P AD=1P PS=5U PD=5U
M$408 \$117 MO5 VSS VSS nfet_03v3 L=0.28U W=3U AS=1.5P AD=1.5P PS=7U PD=7U
M$409 \$175 \$215 VSS VSS nfet_03v3 L=0.28U W=2U AS=1P AD=1P PS=5U PD=5U
M$410 \$176 \$209 VSS VSS nfet_03v3 L=0.28U W=1U AS=0.5P AD=0.5P PS=3U PD=3U
M$411 \$177 CK5 VSS VSS nfet_03v3 L=0.28U W=1U AS=0.5P AD=0.5P PS=3U PD=3U
M$412 \$178 \$177 VSS VSS nfet_03v3 L=0.28U W=1U AS=0.5P AD=0.5P PS=3U PD=3U
M$413 \$179 \$177 \$176 VSS nfet_03v3 L=0.28U W=1U AS=0.5P AD=0.5P PS=3U PD=3U
M$414 \$180 \$179 VSS VSS nfet_03v3 L=0.28U W=1U AS=0.5P AD=0.5P PS=3U PD=3U
M$415 \$181 \$180 VSS VSS nfet_03v3 L=0.28U W=1U AS=0.5P AD=0.5P PS=3U PD=3U
M$416 \$179 \$178 \$181 VSS nfet_03v3 L=0.28U W=1U AS=0.5P AD=0.5P PS=3U PD=3U
M$417 \$182 \$178 \$180 VSS nfet_03v3 L=0.28U W=1U AS=0.5P AD=0.5P PS=3U PD=3U
M$418 \$183 \$182 VSS VSS nfet_03v3 L=0.28U W=1U AS=0.5P AD=0.5P PS=3U PD=3U
M$419 \$208 \$183 VSS VSS nfet_03v3 L=0.28U W=1U AS=0.5P AD=0.5P PS=3U PD=3U
M$420 \$182 \$177 \$208 VSS nfet_03v3 L=0.28U W=1U AS=0.5P AD=0.5P PS=3U PD=3U
M$421 CK6 \$208 VSS VSS nfet_03v3 L=0.28U W=2U AS=1P AD=1P PS=5U PD=5U
M$422 \$184 \$183 VSS VSS nfet_03v3 L=0.28U W=2U AS=1P AD=1P PS=5U PD=5U
M$423 \$185 \$210 VSS VSS nfet_03v3 L=0.28U W=1U AS=0.5P AD=0.5P PS=3U PD=3U
M$424 \$186 CK5 VSS VSS nfet_03v3 L=0.28U W=1U AS=0.5P AD=0.5P PS=3U PD=3U
M$425 \$187 \$186 VSS VSS nfet_03v3 L=0.28U W=1U AS=0.5P AD=0.5P PS=3U PD=3U
M$426 \$188 \$186 \$185 VSS nfet_03v3 L=0.28U W=1U AS=0.5P AD=0.5P PS=3U PD=3U
M$427 \$189 \$188 VSS VSS nfet_03v3 L=0.28U W=1U AS=0.5P AD=0.5P PS=3U PD=3U
M$428 \$190 \$189 VSS VSS nfet_03v3 L=0.28U W=1U AS=0.5P AD=0.5P PS=3U PD=3U
M$429 \$188 \$187 \$190 VSS nfet_03v3 L=0.28U W=1U AS=0.5P AD=0.5P PS=3U PD=3U
M$430 \$191 \$187 \$189 VSS nfet_03v3 L=0.28U W=1U AS=0.5P AD=0.5P PS=3U PD=3U
M$431 MO5 \$191 VSS VSS nfet_03v3 L=0.28U W=1U AS=0.5P AD=0.5P PS=3U PD=3U
M$432 \$192 MO5 VSS VSS nfet_03v3 L=0.28U W=1U AS=0.5P AD=0.5P PS=3U PD=3U
M$433 \$191 \$186 \$192 VSS nfet_03v3 L=0.28U W=1U AS=0.5P AD=0.5P PS=3U PD=3U
M$434 XM5_NMID SEL5 VSS VSS nfet_03v3 L=0.28U W=2U AS=1P AD=1P PS=5U PD=5U
M$435 XMB_NM2 T5 VSS VSS nfet_03v3 L=0.28U W=3U AS=1.5P AD=1.5P PS=7U PD=7U
M$436 \$195 P3 \$110 VSS nfet_03v3 L=0.28U W=3U AS=1.5P AD=1.5P PS=7U PD=7U
M$437 \$213 MI3 \$195 VSS nfet_03v3 L=0.28U W=3U AS=1.5P AD=1.5P PS=7U PD=7U
M$438 \$197 \$196 \$132 VSS nfet_03v3 L=0.28U W=2U AS=1P AD=1P PS=5U PD=5U
M$439 \$198 MI3 \$141 VSS nfet_03v3 L=0.28U W=2U AS=1P AD=1P PS=5U PD=5U
M$440 T3 CK4 XM3_NMID VSS nfet_03v3 L=0.28U W=2U AS=1P AD=1P PS=5U PD=5U
M$441 \$214 MI4 \$201 VSS nfet_03v3 L=0.28U W=3U AS=1.5P AD=1.5P PS=7U PD=7U
M$442 \$201 P4 \$153 VSS nfet_03v3 L=0.28U W=3U AS=1.5P AD=1.5P PS=7U PD=7U
M$443 \$203 \$202 \$154 VSS nfet_03v3 L=0.28U W=2U AS=1P AD=1P PS=5U PD=5U
M$444 \$204 MI4 \$163 VSS nfet_03v3 L=0.28U W=2U AS=1P AD=1P PS=5U PD=5U
M$445 T4 CK5 XM4_NMID VSS nfet_03v3 L=0.28U W=2U AS=1P AD=1P PS=5U PD=5U
M$446 \$215 SEL5 \$207 VSS nfet_03v3 L=0.28U W=3U AS=1.5P AD=1.5P PS=7U PD=7U
M$447 \$207 P5 \$117 VSS nfet_03v3 L=0.28U W=3U AS=1.5P AD=1.5P PS=7U PD=7U
M$448 \$209 \$208 \$175 VSS nfet_03v3 L=0.28U W=2U AS=1P AD=1P PS=5U PD=5U
M$449 \$210 SEL5 \$184 VSS nfet_03v3 L=0.28U W=2U AS=1P AD=1P PS=5U PD=5U
M$450 T5 CK6 XM5_NMID VSS nfet_03v3 L=0.28U W=2U AS=1P AD=1P PS=5U PD=5U
M$451 MB T3 XMB_NM1 VSS nfet_03v3 L=0.28U W=3U AS=1.5P AD=1.5P PS=7U PD=7U
M$452 XMB_NM1 T4 XMB_NM2 VSS nfet_03v3 L=0.28U W=3U AS=1.5P AD=1.5P PS=7U PD=7U
.ENDS divider_chain
