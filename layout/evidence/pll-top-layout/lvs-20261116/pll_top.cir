* Extracted by KLayout with GF180MCU LVS runset on : 16/11/2026 06:34

.SUBCKT pll_top
M$1 \$5.XMNO_PMID \$5.MB \$5.DIVOUTB VDD_DIV pfet_03v3 L=0.28U W=5U AS=2.5P
+ AD=2.5P PS=11U PD=11U
M$2 VDD_DIV \$5.DIVOUTB DIVOUT VDD_DIV pfet_03v3 L=0.28U W=5U AS=2.5P AD=2.5P
+ PS=11U PD=11U
M$3 VDD_DIV \$5.MI0 \$I91 VDD_DIV pfet_03v3 L=0.28U W=2.5U AS=1.25P AD=1.25P
+ PS=6U PD=6U
M$4 VDD_DIV P0 \$I91 VDD_DIV pfet_03v3 L=0.28U W=2.5U AS=1.25P AD=1.25P PS=6U
+ PD=6U
M$5 VDD_DIV \$5.MO0 \$I91 VDD_DIV pfet_03v3 L=0.28U W=2.5U AS=1.25P AD=1.25P
+ PS=6U PD=6U
M$6 VDD_DIV \$I18 \$I19 VDD_DIV pfet_03v3 L=0.28U W=2.5U AS=1.25P AD=1.25P
+ PS=6U PD=6U
M$7 VDD_DIV \$I91 \$I19 VDD_DIV pfet_03v3 L=0.28U W=2.5U AS=1.25P AD=1.25P
+ PS=6U PD=6U
M$8 VDD_DIV \$I19 \$I21 VDD_DIV pfet_03v3 L=0.28U W=2.5U AS=1.25P AD=1.25P
+ PS=6U PD=6U
M$9 VDD_DIV CLK \$I22 VDD_DIV pfet_03v3 L=0.28U W=2.5U AS=1.25P AD=1.25P PS=6U
+ PD=6U
M$10 VDD_DIV \$I22 \$I23 VDD_DIV pfet_03v3 L=0.28U W=2.5U AS=1.25P AD=1.25P
+ PS=6U PD=6U
M$11 \$I21 \$I23 \$I24 VDD_DIV pfet_03v3 L=0.28U W=2.5U AS=1.25P AD=1.25P PS=6U
+ PD=6U
M$12 VDD_DIV \$I24 \$I25 VDD_DIV pfet_03v3 L=0.28U W=2.5U AS=1.25P AD=1.25P
+ PS=6U PD=6U
M$13 VDD_DIV \$I25 \$I26 VDD_DIV pfet_03v3 L=0.28U W=2.5U AS=1.25P AD=1.25P
+ PS=6U PD=6U
M$14 \$I26 \$I22 \$I24 VDD_DIV pfet_03v3 L=0.28U W=2.5U AS=1.25P AD=1.25P PS=6U
+ PD=6U
M$15 \$I25 \$I22 \$I27 VDD_DIV pfet_03v3 L=0.28U W=2.5U AS=1.25P AD=1.25P PS=6U
+ PD=6U
M$16 VDD_DIV \$I27 \$I28 VDD_DIV pfet_03v3 L=0.28U W=2.5U AS=1.25P AD=1.25P
+ PS=6U PD=6U
M$17 VDD_DIV \$I28 \$I18 VDD_DIV pfet_03v3 L=0.28U W=2.5U AS=1.25P AD=1.25P
+ PS=6U PD=6U
M$18 \$I18 \$I23 \$I27 VDD_DIV pfet_03v3 L=0.28U W=2.5U AS=1.25P AD=1.25P PS=6U
+ PD=6U
M$19 VDD_DIV \$I18 \$5.CK1 VDD_DIV pfet_03v3 L=0.28U W=5U AS=2.5P AD=2.5P
+ PS=11U PD=11U
M$20 VDD_DIV \$5.MI0 \$I30 VDD_DIV pfet_03v3 L=0.28U W=2.5U AS=1.25P AD=1.25P
+ PS=6U PD=6U
M$21 VDD_DIV \$I28 \$I30 VDD_DIV pfet_03v3 L=0.28U W=2.5U AS=1.25P AD=1.25P
+ PS=6U PD=6U
M$22 VDD_DIV \$I30 \$I31 VDD_DIV pfet_03v3 L=0.28U W=2.5U AS=1.25P AD=1.25P
+ PS=6U PD=6U
M$23 VDD_DIV CLK \$I32 VDD_DIV pfet_03v3 L=0.28U W=2.5U AS=1.25P AD=1.25P PS=6U
+ PD=6U
M$24 VDD_DIV \$I32 \$I33 VDD_DIV pfet_03v3 L=0.28U W=2.5U AS=1.25P AD=1.25P
+ PS=6U PD=6U
M$25 \$I31 \$I33 \$I34 VDD_DIV pfet_03v3 L=0.28U W=2.5U AS=1.25P AD=1.25P PS=6U
+ PD=6U
M$26 VDD_DIV \$I34 \$I35 VDD_DIV pfet_03v3 L=0.28U W=2.5U AS=1.25P AD=1.25P
+ PS=6U PD=6U
M$27 VDD_DIV \$I35 \$I36 VDD_DIV pfet_03v3 L=0.28U W=2.5U AS=1.25P AD=1.25P
+ PS=6U PD=6U
M$28 \$I36 \$I32 \$I34 VDD_DIV pfet_03v3 L=0.28U W=2.5U AS=1.25P AD=1.25P PS=6U
+ PD=6U
M$29 \$I35 \$I32 \$I37 VDD_DIV pfet_03v3 L=0.28U W=2.5U AS=1.25P AD=1.25P PS=6U
+ PD=6U
M$30 VDD_DIV \$I37 \$5.MO0 VDD_DIV pfet_03v3 L=0.28U W=2.5U AS=1.25P AD=1.25P
+ PS=6U PD=6U
M$31 VDD_DIV \$5.MO0 \$I38 VDD_DIV pfet_03v3 L=0.28U W=2.5U AS=1.25P AD=1.25P
+ PS=6U PD=6U
M$32 \$I38 \$I33 \$I37 VDD_DIV pfet_03v3 L=0.28U W=2.5U AS=1.25P AD=1.25P PS=6U
+ PD=6U
M$33 \$5.XNR0_PMID SEL0 \$5.NMI0 VDD_DIV pfet_03v3 L=0.28U W=5U AS=2.5P AD=2.5P
+ PS=11U PD=11U
M$34 VDD_DIV \$5.NMI0 \$5.MI0 VDD_DIV pfet_03v3 L=0.28U W=2.5U AS=1.25P
+ AD=1.25P PS=6U PD=6U
M$35 VDD_DIV \$5.CK1 \$5.T0 VDD_DIV pfet_03v3 L=0.28U W=2.5U AS=1.25P AD=1.25P
+ PS=6U PD=6U
M$36 VDD_DIV SEL0 \$5.T0 VDD_DIV pfet_03v3 L=0.28U W=2.5U AS=1.25P AD=1.25P
+ PS=6U PD=6U
M$37 VDD_DIV \$5.MI1 \$I93 VDD_DIV pfet_03v3 L=0.28U W=2.5U AS=1.25P AD=1.25P
+ PS=6U PD=6U
M$38 VDD_DIV P1 \$I93 VDD_DIV pfet_03v3 L=0.28U W=2.5U AS=1.25P AD=1.25P PS=6U
+ PD=6U
M$39 VDD_DIV \$5.MO1 \$I93 VDD_DIV pfet_03v3 L=0.28U W=2.5U AS=1.25P AD=1.25P
+ PS=6U PD=6U
M$40 VDD_DIV \$I42 \$I43 VDD_DIV pfet_03v3 L=0.28U W=2.5U AS=1.25P AD=1.25P
+ PS=6U PD=6U
M$41 VDD_DIV \$I93 \$I43 VDD_DIV pfet_03v3 L=0.28U W=2.5U AS=1.25P AD=1.25P
+ PS=6U PD=6U
M$42 VDD_DIV \$I43 \$I45 VDD_DIV pfet_03v3 L=0.28U W=2.5U AS=1.25P AD=1.25P
+ PS=6U PD=6U
M$43 VDD_DIV \$5.CK1 \$I46 VDD_DIV pfet_03v3 L=0.28U W=2.5U AS=1.25P AD=1.25P
+ PS=6U PD=6U
M$44 VDD_DIV \$I46 \$I47 VDD_DIV pfet_03v3 L=0.28U W=2.5U AS=1.25P AD=1.25P
+ PS=6U PD=6U
M$45 \$I45 \$I47 \$I48 VDD_DIV pfet_03v3 L=0.28U W=2.5U AS=1.25P AD=1.25P PS=6U
+ PD=6U
M$46 VDD_DIV \$I48 \$I49 VDD_DIV pfet_03v3 L=0.28U W=2.5U AS=1.25P AD=1.25P
+ PS=6U PD=6U
M$47 VDD_DIV \$I49 \$I96 VDD_DIV pfet_03v3 L=0.28U W=2.5U AS=1.25P AD=1.25P
+ PS=6U PD=6U
M$48 \$I96 \$I46 \$I48 VDD_DIV pfet_03v3 L=0.28U W=2.5U AS=1.25P AD=1.25P PS=6U
+ PD=6U
M$49 \$I49 \$I46 \$I50 VDD_DIV pfet_03v3 L=0.28U W=2.5U AS=1.25P AD=1.25P PS=6U
+ PD=6U
M$50 VDD_DIV \$I50 \$I51 VDD_DIV pfet_03v3 L=0.28U W=2.5U AS=1.25P AD=1.25P
+ PS=6U PD=6U
M$51 VDD_DIV \$I51 \$I42 VDD_DIV pfet_03v3 L=0.28U W=2.5U AS=1.25P AD=1.25P
+ PS=6U PD=6U
M$52 \$I42 \$I47 \$I50 VDD_DIV pfet_03v3 L=0.28U W=2.5U AS=1.25P AD=1.25P PS=6U
+ PD=6U
M$53 VDD_DIV \$I42 \$5.CK2 VDD_DIV pfet_03v3 L=0.28U W=5U AS=2.5P AD=2.5P
+ PS=11U PD=11U
M$54 VDD_DIV \$5.MI1 \$I53 VDD_DIV pfet_03v3 L=0.28U W=2.5U AS=1.25P AD=1.25P
+ PS=6U PD=6U
M$55 VDD_DIV \$I51 \$I53 VDD_DIV pfet_03v3 L=0.28U W=2.5U AS=1.25P AD=1.25P
+ PS=6U PD=6U
M$56 VDD_DIV \$I53 \$I55 VDD_DIV pfet_03v3 L=0.28U W=2.5U AS=1.25P AD=1.25P
+ PS=6U PD=6U
M$57 VDD_DIV \$5.CK1 \$I56 VDD_DIV pfet_03v3 L=0.28U W=2.5U AS=1.25P AD=1.25P
+ PS=6U PD=6U
M$58 VDD_DIV \$I56 \$I57 VDD_DIV pfet_03v3 L=0.28U W=2.5U AS=1.25P AD=1.25P
+ PS=6U PD=6U
M$59 \$I55 \$I57 \$I58 VDD_DIV pfet_03v3 L=0.28U W=2.5U AS=1.25P AD=1.25P PS=6U
+ PD=6U
M$60 VDD_DIV \$I58 \$I59 VDD_DIV pfet_03v3 L=0.28U W=2.5U AS=1.25P AD=1.25P
+ PS=6U PD=6U
M$61 VDD_DIV \$I59 \$I60 VDD_DIV pfet_03v3 L=0.28U W=2.5U AS=1.25P AD=1.25P
+ PS=6U PD=6U
M$62 \$I60 \$I56 \$I58 VDD_DIV pfet_03v3 L=0.28U W=2.5U AS=1.25P AD=1.25P PS=6U
+ PD=6U
M$63 \$I59 \$I56 \$I61 VDD_DIV pfet_03v3 L=0.28U W=2.5U AS=1.25P AD=1.25P PS=6U
+ PD=6U
M$64 VDD_DIV \$I61 \$5.MO1 VDD_DIV pfet_03v3 L=0.28U W=2.5U AS=1.25P AD=1.25P
+ PS=6U PD=6U
M$65 VDD_DIV \$5.MO1 \$I62 VDD_DIV pfet_03v3 L=0.28U W=2.5U AS=1.25P AD=1.25P
+ PS=6U PD=6U
M$66 \$I62 \$I57 \$I61 VDD_DIV pfet_03v3 L=0.28U W=2.5U AS=1.25P AD=1.25P PS=6U
+ PD=6U
M$67 \$5.XNR1_PMID SEL1 \$5.NMI1 VDD_DIV pfet_03v3 L=0.28U W=5U AS=2.5P AD=2.5P
+ PS=11U PD=11U
M$68 VDD_DIV \$5.NMI1 \$5.MI1 VDD_DIV pfet_03v3 L=0.28U W=2.5U AS=1.25P
+ AD=1.25P PS=6U PD=6U
M$69 VDD_DIV \$5.CK2 \$5.T1 VDD_DIV pfet_03v3 L=0.28U W=2.5U AS=1.25P AD=1.25P
+ PS=6U PD=6U
M$70 VDD_DIV SEL1 \$5.T1 VDD_DIV pfet_03v3 L=0.28U W=2.5U AS=1.25P AD=1.25P
+ PS=6U PD=6U
M$71 VDD_DIV \$5.MI2 \$I95 VDD_DIV pfet_03v3 L=0.28U W=2.5U AS=1.25P AD=1.25P
+ PS=6U PD=6U
M$72 VDD_DIV P2 \$I95 VDD_DIV pfet_03v3 L=0.28U W=2.5U AS=1.25P AD=1.25P PS=6U
+ PD=6U
M$73 VDD_DIV \$5.MO2 \$I95 VDD_DIV pfet_03v3 L=0.28U W=2.5U AS=1.25P AD=1.25P
+ PS=6U PD=6U
M$74 VDD_DIV \$I66 \$I68 VDD_DIV pfet_03v3 L=0.28U W=2.5U AS=1.25P AD=1.25P
+ PS=6U PD=6U
M$75 VDD_DIV \$I95 \$I68 VDD_DIV pfet_03v3 L=0.28U W=2.5U AS=1.25P AD=1.25P
+ PS=6U PD=6U
M$76 VDD_DIV \$I68 \$I69 VDD_DIV pfet_03v3 L=0.28U W=2.5U AS=1.25P AD=1.25P
+ PS=6U PD=6U
M$77 VDD_DIV \$5.CK2 \$I70 VDD_DIV pfet_03v3 L=0.28U W=2.5U AS=1.25P AD=1.25P
+ PS=6U PD=6U
M$78 VDD_DIV \$I70 \$I71 VDD_DIV pfet_03v3 L=0.28U W=2.5U AS=1.25P AD=1.25P
+ PS=6U PD=6U
M$79 \$I69 \$I71 \$I72 VDD_DIV pfet_03v3 L=0.28U W=2.5U AS=1.25P AD=1.25P PS=6U
+ PD=6U
M$80 VDD_DIV \$I72 \$I73 VDD_DIV pfet_03v3 L=0.28U W=2.5U AS=1.25P AD=1.25P
+ PS=6U PD=6U
M$81 VDD_DIV \$I73 \$I74 VDD_DIV pfet_03v3 L=0.28U W=2.5U AS=1.25P AD=1.25P
+ PS=6U PD=6U
M$82 \$I74 \$I70 \$I72 VDD_DIV pfet_03v3 L=0.28U W=2.5U AS=1.25P AD=1.25P PS=6U
+ PD=6U
M$83 \$I73 \$I70 \$I75 VDD_DIV pfet_03v3 L=0.28U W=2.5U AS=1.25P AD=1.25P PS=6U
+ PD=6U
M$84 VDD_DIV \$I75 \$I76 VDD_DIV pfet_03v3 L=0.28U W=2.5U AS=1.25P AD=1.25P
+ PS=6U PD=6U
M$85 VDD_DIV \$I76 \$I66 VDD_DIV pfet_03v3 L=0.28U W=2.5U AS=1.25P AD=1.25P
+ PS=6U PD=6U
M$86 \$I66 \$I71 \$I75 VDD_DIV pfet_03v3 L=0.28U W=2.5U AS=1.25P AD=1.25P PS=6U
+ PD=6U
M$87 VDD_DIV \$I66 \$5.CK3 VDD_DIV pfet_03v3 L=0.28U W=5U AS=2.5P AD=2.5P
+ PS=11U PD=11U
M$88 VDD_DIV \$5.MI2 \$I79 VDD_DIV pfet_03v3 L=0.28U W=2.5U AS=1.25P AD=1.25P
+ PS=6U PD=6U
M$89 VDD_DIV \$I76 \$I79 VDD_DIV pfet_03v3 L=0.28U W=2.5U AS=1.25P AD=1.25P
+ PS=6U PD=6U
M$90 VDD_DIV \$I79 \$I80 VDD_DIV pfet_03v3 L=0.28U W=2.5U AS=1.25P AD=1.25P
+ PS=6U PD=6U
M$91 VDD_DIV \$5.CK2 \$I81 VDD_DIV pfet_03v3 L=0.28U W=2.5U AS=1.25P AD=1.25P
+ PS=6U PD=6U
M$92 VDD_DIV \$I81 \$I82 VDD_DIV pfet_03v3 L=0.28U W=2.5U AS=1.25P AD=1.25P
+ PS=6U PD=6U
M$93 \$I80 \$I82 \$I83 VDD_DIV pfet_03v3 L=0.28U W=2.5U AS=1.25P AD=1.25P PS=6U
+ PD=6U
M$94 VDD_DIV \$I83 \$I84 VDD_DIV pfet_03v3 L=0.28U W=2.5U AS=1.25P AD=1.25P
+ PS=6U PD=6U
M$95 VDD_DIV \$I84 \$I85 VDD_DIV pfet_03v3 L=0.28U W=2.5U AS=1.25P AD=1.25P
+ PS=6U PD=6U
M$96 \$I85 \$I81 \$I83 VDD_DIV pfet_03v3 L=0.28U W=2.5U AS=1.25P AD=1.25P PS=6U
+ PD=6U
M$97 \$I84 \$I81 \$I86 VDD_DIV pfet_03v3 L=0.28U W=2.5U AS=1.25P AD=1.25P PS=6U
+ PD=6U
M$98 VDD_DIV \$I86 \$5.MO2 VDD_DIV pfet_03v3 L=0.28U W=2.5U AS=1.25P AD=1.25P
+ PS=6U PD=6U
M$99 VDD_DIV \$5.MO2 \$I87 VDD_DIV pfet_03v3 L=0.28U W=2.5U AS=1.25P AD=1.25P
+ PS=6U PD=6U
M$100 \$I87 \$I82 \$I86 VDD_DIV pfet_03v3 L=0.28U W=2.5U AS=1.25P AD=1.25P
+ PS=6U PD=6U
M$101 \$5.XNR2_PMID SEL2 \$5.NMI2 VDD_DIV pfet_03v3 L=0.28U W=5U AS=2.5P
+ AD=2.5P PS=11U PD=11U
M$102 VDD_DIV \$5.NMI2 \$5.MI2 VDD_DIV pfet_03v3 L=0.28U W=2.5U AS=1.25P
+ AD=1.25P PS=6U PD=6U
M$103 VDD_DIV \$5.CK3 \$5.T2 VDD_DIV pfet_03v3 L=0.28U W=2.5U AS=1.25P AD=1.25P
+ PS=6U PD=6U
M$104 VDD_DIV SEL2 \$5.T2 VDD_DIV pfet_03v3 L=0.28U W=2.5U AS=1.25P AD=1.25P
+ PS=6U PD=6U
M$105 VDD_DIV \$5.T0 \$5.MA VDD_DIV pfet_03v3 L=0.28U W=2.5U AS=1.25P AD=1.25P
+ PS=6U PD=6U
M$106 VDD_DIV \$5.T1 \$5.MA VDD_DIV pfet_03v3 L=0.28U W=2.5U AS=1.25P AD=1.25P
+ PS=6U PD=6U
M$107 VDD_DIV \$5.T2 \$5.MA VDD_DIV pfet_03v3 L=0.28U W=2.5U AS=1.25P AD=1.25P
+ PS=6U PD=6U
M$108 VDD_DIV \$5.MA \$5.XMNO_PMID VDD_DIV pfet_03v3 L=0.28U W=5U AS=2.5P
+ AD=2.5P PS=11U PD=11U
M$109 VDD_DIV \$5.MO1 \$5.XNR0_PMID VDD_DIV pfet_03v3 L=0.28U W=5U AS=2.5P
+ AD=2.5P PS=11U PD=11U
M$110 VDD_DIV \$5.MO2 \$5.XNR1_PMID VDD_DIV pfet_03v3 L=0.28U W=5U AS=2.5P
+ AD=2.5P PS=11U PD=11U
M$111 VDD_DIV \$5.MO3 \$5.XNR2_PMID VDD_DIV pfet_03v3 L=0.28U W=5U AS=2.5P
+ AD=2.5P PS=11U PD=11U
M$112 VDD_DIV CLK \$5.XFRT_CKB VDD_DIV pfet_03v3 L=0.28U W=2.5U AS=1.25P
+ AD=1.25P PS=6U PD=6U
M$113 VDD_DIV \$5.XFRT_CKB \$5.XFRT_CKBB VDD_DIV pfet_03v3 L=0.28U W=2.5U
+ AS=1.25P AD=1.25P PS=6U PD=6U
M$114 DIVOUT \$5.XFRT_CKBB \$5.XFRT_NM VDD_DIV pfet_03v3 L=0.28U W=2.5U
+ AS=1.25P AD=1.25P PS=6U PD=6U
M$115 VDD_DIV \$5.XFRT_NM \$5.XFRT_NMA VDD_DIV pfet_03v3 L=0.28U W=2.5U
+ AS=1.25P AD=1.25P PS=6U PD=6U
M$116 VDD_DIV \$5.XFRT_NMA \$5.XFRT_NMB VDD_DIV pfet_03v3 L=0.28U W=2.5U
+ AS=1.25P AD=1.25P PS=6U PD=6U
M$117 \$5.XFRT_NMB \$5.XFRT_CKB \$5.XFRT_NM VDD_DIV pfet_03v3 L=0.28U W=2.5U
+ AS=1.25P AD=1.25P PS=6U PD=6U
M$118 \$5.XFRT_NMA \$5.XFRT_CKB \$5.XFRT_NS VDD_DIV pfet_03v3 L=0.28U W=2.5U
+ AS=1.25P AD=1.25P PS=6U PD=6U
M$119 VDD_DIV \$5.XFRT_NS FB VDD_DIV pfet_03v3 L=0.28U W=2.5U AS=1.25P AD=1.25P
+ PS=6U PD=6U
M$120 VDD_DIV FB \$5.FBB VDD_DIV pfet_03v3 L=0.28U W=2.5U AS=1.25P AD=1.25P
+ PS=6U PD=6U
M$121 \$5.FBB \$5.XFRT_CKBB \$5.XFRT_NS VDD_DIV pfet_03v3 L=0.28U W=2.5U
+ AS=1.25P AD=1.25P PS=6U PD=6U
M$122 VDD_DIV \$5.MI3 \$I195 VDD_DIV pfet_03v3 L=0.28U W=2.5U AS=1.25P AD=1.25P
+ PS=6U PD=6U
M$123 VDD_DIV P3 \$I195 VDD_DIV pfet_03v3 L=0.28U W=2.5U AS=1.25P AD=1.25P
+ PS=6U PD=6U
M$124 VDD_DIV \$5.MO3 \$I195 VDD_DIV pfet_03v3 L=0.28U W=2.5U AS=1.25P AD=1.25P
+ PS=6U PD=6U
M$125 VDD_DIV \$I113 \$I182 VDD_DIV pfet_03v3 L=0.28U W=2.5U AS=1.25P AD=1.25P
+ PS=6U PD=6U
M$126 VDD_DIV \$I195 \$I182 VDD_DIV pfet_03v3 L=0.28U W=2.5U AS=1.25P AD=1.25P
+ PS=6U PD=6U
M$127 VDD_DIV \$I182 \$I115 VDD_DIV pfet_03v3 L=0.28U W=2.5U AS=1.25P AD=1.25P
+ PS=6U PD=6U
M$128 VDD_DIV \$5.CK3 \$I116 VDD_DIV pfet_03v3 L=0.28U W=2.5U AS=1.25P AD=1.25P
+ PS=6U PD=6U
M$129 VDD_DIV \$I116 \$I117 VDD_DIV pfet_03v3 L=0.28U W=2.5U AS=1.25P AD=1.25P
+ PS=6U PD=6U
M$130 \$I115 \$I117 \$I118 VDD_DIV pfet_03v3 L=0.28U W=2.5U AS=1.25P AD=1.25P
+ PS=6U PD=6U
M$131 VDD_DIV \$I118 \$I119 VDD_DIV pfet_03v3 L=0.28U W=2.5U AS=1.25P AD=1.25P
+ PS=6U PD=6U
M$132 VDD_DIV \$I119 \$I120 VDD_DIV pfet_03v3 L=0.28U W=2.5U AS=1.25P AD=1.25P
+ PS=6U PD=6U
M$133 \$I120 \$I116 \$I118 VDD_DIV pfet_03v3 L=0.28U W=2.5U AS=1.25P AD=1.25P
+ PS=6U PD=6U
M$134 \$I119 \$I116 \$I121 VDD_DIV pfet_03v3 L=0.28U W=2.5U AS=1.25P AD=1.25P
+ PS=6U PD=6U
M$135 VDD_DIV \$I121 \$I122 VDD_DIV pfet_03v3 L=0.28U W=2.5U AS=1.25P AD=1.25P
+ PS=6U PD=6U
M$136 VDD_DIV \$I122 \$I113 VDD_DIV pfet_03v3 L=0.28U W=2.5U AS=1.25P AD=1.25P
+ PS=6U PD=6U
M$137 \$I113 \$I117 \$I121 VDD_DIV pfet_03v3 L=0.28U W=2.5U AS=1.25P AD=1.25P
+ PS=6U PD=6U
M$138 VDD_DIV \$I113 \$5.CK4 VDD_DIV pfet_03v3 L=0.28U W=5U AS=2.5P AD=2.5P
+ PS=11U PD=11U
M$139 VDD_DIV \$5.MI3 \$I183 VDD_DIV pfet_03v3 L=0.28U W=2.5U AS=1.25P AD=1.25P
+ PS=6U PD=6U
M$140 VDD_DIV \$I122 \$I183 VDD_DIV pfet_03v3 L=0.28U W=2.5U AS=1.25P AD=1.25P
+ PS=6U PD=6U
M$141 VDD_DIV \$I183 \$I125 VDD_DIV pfet_03v3 L=0.28U W=2.5U AS=1.25P AD=1.25P
+ PS=6U PD=6U
M$142 VDD_DIV \$5.CK3 \$I126 VDD_DIV pfet_03v3 L=0.28U W=2.5U AS=1.25P AD=1.25P
+ PS=6U PD=6U
M$143 VDD_DIV \$I126 \$I127 VDD_DIV pfet_03v3 L=0.28U W=2.5U AS=1.25P AD=1.25P
+ PS=6U PD=6U
M$144 \$I125 \$I127 \$I128 VDD_DIV pfet_03v3 L=0.28U W=2.5U AS=1.25P AD=1.25P
+ PS=6U PD=6U
M$145 VDD_DIV \$I128 \$I129 VDD_DIV pfet_03v3 L=0.28U W=2.5U AS=1.25P AD=1.25P
+ PS=6U PD=6U
M$146 VDD_DIV \$I129 \$I130 VDD_DIV pfet_03v3 L=0.28U W=2.5U AS=1.25P AD=1.25P
+ PS=6U PD=6U
M$147 \$I130 \$I126 \$I128 VDD_DIV pfet_03v3 L=0.28U W=2.5U AS=1.25P AD=1.25P
+ PS=6U PD=6U
M$148 \$I129 \$I126 \$I131 VDD_DIV pfet_03v3 L=0.28U W=2.5U AS=1.25P AD=1.25P
+ PS=6U PD=6U
M$149 VDD_DIV \$I131 \$5.MO3 VDD_DIV pfet_03v3 L=0.28U W=2.5U AS=1.25P AD=1.25P
+ PS=6U PD=6U
M$150 VDD_DIV \$5.MO3 \$I132 VDD_DIV pfet_03v3 L=0.28U W=2.5U AS=1.25P AD=1.25P
+ PS=6U PD=6U
M$151 \$I132 \$I127 \$I131 VDD_DIV pfet_03v3 L=0.28U W=2.5U AS=1.25P AD=1.25P
+ PS=6U PD=6U
M$152 \$5.XNR3_PMID SEL3 \$5.NMI3 VDD_DIV pfet_03v3 L=0.28U W=5U AS=2.5P
+ AD=2.5P PS=11U PD=11U
M$153 VDD_DIV \$5.NMI3 \$5.MI3 VDD_DIV pfet_03v3 L=0.28U W=2.5U AS=1.25P
+ AD=1.25P PS=6U PD=6U
M$154 VDD_DIV \$5.CK4 \$5.T3 VDD_DIV pfet_03v3 L=0.28U W=2.5U AS=1.25P AD=1.25P
+ PS=6U PD=6U
M$155 VDD_DIV SEL3 \$5.T3 VDD_DIV pfet_03v3 L=0.28U W=2.5U AS=1.25P AD=1.25P
+ PS=6U PD=6U
M$156 VDD_DIV \$5.MI4 \$I196 VDD_DIV pfet_03v3 L=0.28U W=2.5U AS=1.25P AD=1.25P
+ PS=6U PD=6U
M$157 VDD_DIV P4 \$I196 VDD_DIV pfet_03v3 L=0.28U W=2.5U AS=1.25P AD=1.25P
+ PS=6U PD=6U
M$158 VDD_DIV \$5.MO4 \$I196 VDD_DIV pfet_03v3 L=0.28U W=2.5U AS=1.25P AD=1.25P
+ PS=6U PD=6U
M$159 VDD_DIV \$I137 \$I187 VDD_DIV pfet_03v3 L=0.28U W=2.5U AS=1.25P AD=1.25P
+ PS=6U PD=6U
M$160 VDD_DIV \$I196 \$I187 VDD_DIV pfet_03v3 L=0.28U W=2.5U AS=1.25P AD=1.25P
+ PS=6U PD=6U
M$161 VDD_DIV \$I187 \$I139 VDD_DIV pfet_03v3 L=0.28U W=2.5U AS=1.25P AD=1.25P
+ PS=6U PD=6U
M$162 VDD_DIV \$5.CK4 \$I140 VDD_DIV pfet_03v3 L=0.28U W=2.5U AS=1.25P AD=1.25P
+ PS=6U PD=6U
M$163 VDD_DIV \$I140 \$I141 VDD_DIV pfet_03v3 L=0.28U W=2.5U AS=1.25P AD=1.25P
+ PS=6U PD=6U
M$164 \$I139 \$I141 \$I142 VDD_DIV pfet_03v3 L=0.28U W=2.5U AS=1.25P AD=1.25P
+ PS=6U PD=6U
M$165 VDD_DIV \$I142 \$I143 VDD_DIV pfet_03v3 L=0.28U W=2.5U AS=1.25P AD=1.25P
+ PS=6U PD=6U
M$166 VDD_DIV \$I143 \$I144 VDD_DIV pfet_03v3 L=0.28U W=2.5U AS=1.25P AD=1.25P
+ PS=6U PD=6U
M$167 \$I144 \$I140 \$I142 VDD_DIV pfet_03v3 L=0.28U W=2.5U AS=1.25P AD=1.25P
+ PS=6U PD=6U
M$168 \$I143 \$I140 \$I145 VDD_DIV pfet_03v3 L=0.28U W=2.5U AS=1.25P AD=1.25P
+ PS=6U PD=6U
M$169 VDD_DIV \$I145 \$I146 VDD_DIV pfet_03v3 L=0.28U W=2.5U AS=1.25P AD=1.25P
+ PS=6U PD=6U
M$170 VDD_DIV \$I146 \$I137 VDD_DIV pfet_03v3 L=0.28U W=2.5U AS=1.25P AD=1.25P
+ PS=6U PD=6U
M$171 \$I137 \$I141 \$I145 VDD_DIV pfet_03v3 L=0.28U W=2.5U AS=1.25P AD=1.25P
+ PS=6U PD=6U
M$172 VDD_DIV \$I137 \$5.CK5 VDD_DIV pfet_03v3 L=0.28U W=5U AS=2.5P AD=2.5P
+ PS=11U PD=11U
M$173 VDD_DIV \$5.MI4 \$I188 VDD_DIV pfet_03v3 L=0.28U W=2.5U AS=1.25P AD=1.25P
+ PS=6U PD=6U
M$174 VDD_DIV \$I146 \$I188 VDD_DIV pfet_03v3 L=0.28U W=2.5U AS=1.25P AD=1.25P
+ PS=6U PD=6U
M$175 VDD_DIV \$I188 \$I148 VDD_DIV pfet_03v3 L=0.28U W=2.5U AS=1.25P AD=1.25P
+ PS=6U PD=6U
M$176 VDD_DIV \$5.CK4 \$I149 VDD_DIV pfet_03v3 L=0.28U W=2.5U AS=1.25P AD=1.25P
+ PS=6U PD=6U
M$177 VDD_DIV \$I149 \$I150 VDD_DIV pfet_03v3 L=0.28U W=2.5U AS=1.25P AD=1.25P
+ PS=6U PD=6U
M$178 \$I148 \$I150 \$I151 VDD_DIV pfet_03v3 L=0.28U W=2.5U AS=1.25P AD=1.25P
+ PS=6U PD=6U
M$179 VDD_DIV \$I151 \$I152 VDD_DIV pfet_03v3 L=0.28U W=2.5U AS=1.25P AD=1.25P
+ PS=6U PD=6U
M$180 VDD_DIV \$I152 \$I153 VDD_DIV pfet_03v3 L=0.28U W=2.5U AS=1.25P AD=1.25P
+ PS=6U PD=6U
M$181 \$I153 \$I149 \$I151 VDD_DIV pfet_03v3 L=0.28U W=2.5U AS=1.25P AD=1.25P
+ PS=6U PD=6U
M$182 \$I152 \$I149 \$I154 VDD_DIV pfet_03v3 L=0.28U W=2.5U AS=1.25P AD=1.25P
+ PS=6U PD=6U
M$183 VDD_DIV \$I154 \$5.MO4 VDD_DIV pfet_03v3 L=0.28U W=2.5U AS=1.25P AD=1.25P
+ PS=6U PD=6U
M$184 VDD_DIV \$5.MO4 \$I155 VDD_DIV pfet_03v3 L=0.28U W=2.5U AS=1.25P AD=1.25P
+ PS=6U PD=6U
M$185 \$I155 \$I150 \$I154 VDD_DIV pfet_03v3 L=0.28U W=2.5U AS=1.25P AD=1.25P
+ PS=6U PD=6U
M$186 \$5.XNR4_PMID SEL4 \$5.NMI4 VDD_DIV pfet_03v3 L=0.28U W=5U AS=2.5P
+ AD=2.5P PS=11U PD=11U
M$187 VDD_DIV \$5.NMI4 \$5.MI4 VDD_DIV pfet_03v3 L=0.28U W=2.5U AS=1.25P
+ AD=1.25P PS=6U PD=6U
M$188 VDD_DIV \$5.CK5 \$5.T4 VDD_DIV pfet_03v3 L=0.28U W=2.5U AS=1.25P AD=1.25P
+ PS=6U PD=6U
M$189 VDD_DIV SEL4 \$5.T4 VDD_DIV pfet_03v3 L=0.28U W=2.5U AS=1.25P AD=1.25P
+ PS=6U PD=6U
M$190 VDD_DIV SEL5 \$I197 VDD_DIV pfet_03v3 L=0.28U W=2.5U AS=1.25P AD=1.25P
+ PS=6U PD=6U
M$191 VDD_DIV P5 \$I197 VDD_DIV pfet_03v3 L=0.28U W=2.5U AS=1.25P AD=1.25P
+ PS=6U PD=6U
M$192 VDD_DIV \$5.MO5 \$I197 VDD_DIV pfet_03v3 L=0.28U W=2.5U AS=1.25P AD=1.25P
+ PS=6U PD=6U
M$193 VDD_DIV \$I158 \$I191 VDD_DIV pfet_03v3 L=0.28U W=2.5U AS=1.25P AD=1.25P
+ PS=6U PD=6U
M$194 VDD_DIV \$I197 \$I191 VDD_DIV pfet_03v3 L=0.28U W=2.5U AS=1.25P AD=1.25P
+ PS=6U PD=6U
M$195 VDD_DIV \$I191 \$I160 VDD_DIV pfet_03v3 L=0.28U W=2.5U AS=1.25P AD=1.25P
+ PS=6U PD=6U
M$196 VDD_DIV \$5.CK5 \$I161 VDD_DIV pfet_03v3 L=0.28U W=2.5U AS=1.25P AD=1.25P
+ PS=6U PD=6U
M$197 VDD_DIV \$I161 \$I162 VDD_DIV pfet_03v3 L=0.28U W=2.5U AS=1.25P AD=1.25P
+ PS=6U PD=6U
M$198 \$I160 \$I162 \$I163 VDD_DIV pfet_03v3 L=0.28U W=2.5U AS=1.25P AD=1.25P
+ PS=6U PD=6U
M$199 VDD_DIV \$I163 \$I164 VDD_DIV pfet_03v3 L=0.28U W=2.5U AS=1.25P AD=1.25P
+ PS=6U PD=6U
M$200 VDD_DIV \$I164 \$I165 VDD_DIV pfet_03v3 L=0.28U W=2.5U AS=1.25P AD=1.25P
+ PS=6U PD=6U
M$201 \$I165 \$I161 \$I163 VDD_DIV pfet_03v3 L=0.28U W=2.5U AS=1.25P AD=1.25P
+ PS=6U PD=6U
M$202 \$I164 \$I161 \$I166 VDD_DIV pfet_03v3 L=0.28U W=2.5U AS=1.25P AD=1.25P
+ PS=6U PD=6U
M$203 VDD_DIV \$I166 \$I167 VDD_DIV pfet_03v3 L=0.28U W=2.5U AS=1.25P AD=1.25P
+ PS=6U PD=6U
M$204 VDD_DIV \$I167 \$I158 VDD_DIV pfet_03v3 L=0.28U W=2.5U AS=1.25P AD=1.25P
+ PS=6U PD=6U
M$205 \$I158 \$I162 \$I166 VDD_DIV pfet_03v3 L=0.28U W=2.5U AS=1.25P AD=1.25P
+ PS=6U PD=6U
M$206 VDD_DIV \$I158 \$5.CK6 VDD_DIV pfet_03v3 L=0.28U W=5U AS=2.5P AD=2.5P
+ PS=11U PD=11U
M$207 VDD_DIV SEL5 \$I192 VDD_DIV pfet_03v3 L=0.28U W=2.5U AS=1.25P AD=1.25P
+ PS=6U PD=6U
M$208 VDD_DIV \$I167 \$I192 VDD_DIV pfet_03v3 L=0.28U W=2.5U AS=1.25P AD=1.25P
+ PS=6U PD=6U
M$209 VDD_DIV \$I192 \$I170 VDD_DIV pfet_03v3 L=0.28U W=2.5U AS=1.25P AD=1.25P
+ PS=6U PD=6U
M$210 VDD_DIV \$5.CK5 \$I171 VDD_DIV pfet_03v3 L=0.28U W=2.5U AS=1.25P AD=1.25P
+ PS=6U PD=6U
M$211 VDD_DIV \$I171 \$I172 VDD_DIV pfet_03v3 L=0.28U W=2.5U AS=1.25P AD=1.25P
+ PS=6U PD=6U
M$212 \$I170 \$I172 \$I173 VDD_DIV pfet_03v3 L=0.28U W=2.5U AS=1.25P AD=1.25P
+ PS=6U PD=6U
M$213 VDD_DIV \$I173 \$I174 VDD_DIV pfet_03v3 L=0.28U W=2.5U AS=1.25P AD=1.25P
+ PS=6U PD=6U
M$214 VDD_DIV \$I174 \$I175 VDD_DIV pfet_03v3 L=0.28U W=2.5U AS=1.25P AD=1.25P
+ PS=6U PD=6U
M$215 \$I175 \$I171 \$I173 VDD_DIV pfet_03v3 L=0.28U W=2.5U AS=1.25P AD=1.25P
+ PS=6U PD=6U
M$216 \$I174 \$I171 \$I176 VDD_DIV pfet_03v3 L=0.28U W=2.5U AS=1.25P AD=1.25P
+ PS=6U PD=6U
M$217 VDD_DIV \$I176 \$5.MO5 VDD_DIV pfet_03v3 L=0.28U W=2.5U AS=1.25P AD=1.25P
+ PS=6U PD=6U
M$218 VDD_DIV \$5.MO5 \$I177 VDD_DIV pfet_03v3 L=0.28U W=2.5U AS=1.25P AD=1.25P
+ PS=6U PD=6U
M$219 \$I177 \$I172 \$I176 VDD_DIV pfet_03v3 L=0.28U W=2.5U AS=1.25P AD=1.25P
+ PS=6U PD=6U
M$220 VDD_DIV \$5.CK6 \$5.T5 VDD_DIV pfet_03v3 L=0.28U W=2.5U AS=1.25P AD=1.25P
+ PS=6U PD=6U
M$221 VDD_DIV SEL5 \$5.T5 VDD_DIV pfet_03v3 L=0.28U W=2.5U AS=1.25P AD=1.25P
+ PS=6U PD=6U
M$222 VDD_DIV \$5.T3 \$5.MB VDD_DIV pfet_03v3 L=0.28U W=2.5U AS=1.25P AD=1.25P
+ PS=6U PD=6U
M$223 VDD_DIV \$5.T4 \$5.MB VDD_DIV pfet_03v3 L=0.28U W=2.5U AS=1.25P AD=1.25P
+ PS=6U PD=6U
M$224 VDD_DIV \$5.T5 \$5.MB VDD_DIV pfet_03v3 L=0.28U W=2.5U AS=1.25P AD=1.25P
+ PS=6U PD=6U
M$225 VDD_DIV \$5.MO4 \$5.XNR3_PMID VDD_DIV pfet_03v3 L=0.28U W=5U AS=2.5P
+ AD=2.5P PS=11U PD=11U
M$226 VDD_DIV \$5.MO5 \$5.XNR4_PMID VDD_DIV pfet_03v3 L=0.28U W=5U AS=2.5P
+ AD=2.5P PS=11U PD=11U
M$227 \$5.DIVOUTB \$5.MA GND_VCO|VSS GND_VCO|VSS nfet_03v3 L=0.28U W=1U AS=0.5P
+ AD=0.5P PS=3U PD=3U
M$228 \$5.DIVOUTB \$5.MB GND_VCO|VSS GND_VCO|VSS nfet_03v3 L=0.28U W=1U AS=0.5P
+ AD=0.5P PS=3U PD=3U
M$229 DIVOUT \$5.DIVOUTB GND_VCO|VSS GND_VCO|VSS nfet_03v3 L=0.28U W=2U AS=1P
+ AD=1P PS=5U PD=5U
M$230 \$I17 \$5.MO0 GND_VCO|VSS GND_VCO|VSS nfet_03v3 L=0.28U W=3U AS=1.5P
+ AD=1.5P PS=7U PD=7U
M$231 \$I20 \$I91 GND_VCO|VSS GND_VCO|VSS nfet_03v3 L=0.28U W=2U AS=1P AD=1P
+ PS=5U PD=5U
M$232 \$I21 \$I19 GND_VCO|VSS GND_VCO|VSS nfet_03v3 L=0.28U W=1U AS=0.5P
+ AD=0.5P PS=3U PD=3U
M$233 \$I22 CLK GND_VCO|VSS GND_VCO|VSS nfet_03v3 L=0.28U W=1U AS=0.5P AD=0.5P
+ PS=3U PD=3U
M$234 \$I23 \$I22 GND_VCO|VSS GND_VCO|VSS nfet_03v3 L=0.28U W=1U AS=0.5P
+ AD=0.5P PS=3U PD=3U
M$235 \$I24 \$I22 \$I21 GND_VCO|VSS nfet_03v3 L=0.28U W=1U AS=0.5P AD=0.5P
+ PS=3U PD=3U
M$236 \$I25 \$I24 GND_VCO|VSS GND_VCO|VSS nfet_03v3 L=0.28U W=1U AS=0.5P
+ AD=0.5P PS=3U PD=3U
M$237 \$I26 \$I25 GND_VCO|VSS GND_VCO|VSS nfet_03v3 L=0.28U W=1U AS=0.5P
+ AD=0.5P PS=3U PD=3U
M$238 \$I24 \$I23 \$I26 GND_VCO|VSS nfet_03v3 L=0.28U W=1U AS=0.5P AD=0.5P
+ PS=3U PD=3U
M$239 \$I27 \$I23 \$I25 GND_VCO|VSS nfet_03v3 L=0.28U W=1U AS=0.5P AD=0.5P
+ PS=3U PD=3U
M$240 \$I28 \$I27 GND_VCO|VSS GND_VCO|VSS nfet_03v3 L=0.28U W=1U AS=0.5P
+ AD=0.5P PS=3U PD=3U
M$241 \$I18 \$I28 GND_VCO|VSS GND_VCO|VSS nfet_03v3 L=0.28U W=1U AS=0.5P
+ AD=0.5P PS=3U PD=3U
M$242 \$I27 \$I22 \$I18 GND_VCO|VSS nfet_03v3 L=0.28U W=1U AS=0.5P AD=0.5P
+ PS=3U PD=3U
M$243 \$5.CK1 \$I18 GND_VCO|VSS GND_VCO|VSS nfet_03v3 L=0.28U W=2U AS=1P AD=1P
+ PS=5U PD=5U
M$244 \$I29 \$I28 GND_VCO|VSS GND_VCO|VSS nfet_03v3 L=0.28U W=2U AS=1P AD=1P
+ PS=5U PD=5U
M$245 \$I31 \$I30 GND_VCO|VSS GND_VCO|VSS nfet_03v3 L=0.28U W=1U AS=0.5P
+ AD=0.5P PS=3U PD=3U
M$246 \$I32 CLK GND_VCO|VSS GND_VCO|VSS nfet_03v3 L=0.28U W=1U AS=0.5P AD=0.5P
+ PS=3U PD=3U
M$247 \$I33 \$I32 GND_VCO|VSS GND_VCO|VSS nfet_03v3 L=0.28U W=1U AS=0.5P
+ AD=0.5P PS=3U PD=3U
M$248 \$I34 \$I32 \$I31 GND_VCO|VSS nfet_03v3 L=0.28U W=1U AS=0.5P AD=0.5P
+ PS=3U PD=3U
M$249 \$I35 \$I34 GND_VCO|VSS GND_VCO|VSS nfet_03v3 L=0.28U W=1U AS=0.5P
+ AD=0.5P PS=3U PD=3U
M$250 \$I36 \$I35 GND_VCO|VSS GND_VCO|VSS nfet_03v3 L=0.28U W=1U AS=0.5P
+ AD=0.5P PS=3U PD=3U
M$251 \$I34 \$I33 \$I36 GND_VCO|VSS nfet_03v3 L=0.28U W=1U AS=0.5P AD=0.5P
+ PS=3U PD=3U
M$252 \$I37 \$I33 \$I35 GND_VCO|VSS nfet_03v3 L=0.28U W=1U AS=0.5P AD=0.5P
+ PS=3U PD=3U
M$253 \$5.MO0 \$I37 GND_VCO|VSS GND_VCO|VSS nfet_03v3 L=0.28U W=1U AS=0.5P
+ AD=0.5P PS=3U PD=3U
M$254 \$I38 \$5.MO0 GND_VCO|VSS GND_VCO|VSS nfet_03v3 L=0.28U W=1U AS=0.5P
+ AD=0.5P PS=3U PD=3U
M$255 \$I37 \$I32 \$I38 GND_VCO|VSS nfet_03v3 L=0.28U W=1U AS=0.5P AD=0.5P
+ PS=3U PD=3U
M$256 \$5.NMI0 \$5.MO1 GND_VCO|VSS GND_VCO|VSS nfet_03v3 L=0.28U W=1U AS=0.5P
+ AD=0.5P PS=3U PD=3U
M$257 \$5.NMI0 SEL0 GND_VCO|VSS GND_VCO|VSS nfet_03v3 L=0.28U W=1U AS=0.5P
+ AD=0.5P PS=3U PD=3U
M$258 \$5.MI0 \$5.NMI0 GND_VCO|VSS GND_VCO|VSS nfet_03v3 L=0.28U W=1U AS=0.5P
+ AD=0.5P PS=3U PD=3U
M$259 \$5.XM0_NMID SEL0 GND_VCO|VSS GND_VCO|VSS nfet_03v3 L=0.28U W=2U AS=1P
+ AD=1P PS=5U PD=5U
M$260 \$I40 \$5.MO1 GND_VCO|VSS GND_VCO|VSS nfet_03v3 L=0.28U W=3U AS=1.5P
+ AD=1.5P PS=7U PD=7U
M$261 \$I44 \$I93 GND_VCO|VSS GND_VCO|VSS nfet_03v3 L=0.28U W=2U AS=1P AD=1P
+ PS=5U PD=5U
M$262 \$I45 \$I43 GND_VCO|VSS GND_VCO|VSS nfet_03v3 L=0.28U W=1U AS=0.5P
+ AD=0.5P PS=3U PD=3U
M$263 \$I46 \$5.CK1 GND_VCO|VSS GND_VCO|VSS nfet_03v3 L=0.28U W=1U AS=0.5P
+ AD=0.5P PS=3U PD=3U
M$264 \$I47 \$I46 GND_VCO|VSS GND_VCO|VSS nfet_03v3 L=0.28U W=1U AS=0.5P
+ AD=0.5P PS=3U PD=3U
M$265 \$I48 \$I46 \$I45 GND_VCO|VSS nfet_03v3 L=0.28U W=1U AS=0.5P AD=0.5P
+ PS=3U PD=3U
M$266 \$I49 \$I48 GND_VCO|VSS GND_VCO|VSS nfet_03v3 L=0.28U W=1U AS=0.5P
+ AD=0.5P PS=3U PD=3U
M$267 \$I96 \$I49 GND_VCO|VSS GND_VCO|VSS nfet_03v3 L=0.28U W=1U AS=0.5P
+ AD=0.5P PS=3U PD=3U
M$268 \$I48 \$I47 \$I96 GND_VCO|VSS nfet_03v3 L=0.28U W=1U AS=0.5P AD=0.5P
+ PS=3U PD=3U
M$269 \$I50 \$I47 \$I49 GND_VCO|VSS nfet_03v3 L=0.28U W=1U AS=0.5P AD=0.5P
+ PS=3U PD=3U
M$270 \$I51 \$I50 GND_VCO|VSS GND_VCO|VSS nfet_03v3 L=0.28U W=1U AS=0.5P
+ AD=0.5P PS=3U PD=3U
M$271 \$I42 \$I51 GND_VCO|VSS GND_VCO|VSS nfet_03v3 L=0.28U W=1U AS=0.5P
+ AD=0.5P PS=3U PD=3U
M$272 \$I50 \$I46 \$I42 GND_VCO|VSS nfet_03v3 L=0.28U W=1U AS=0.5P AD=0.5P
+ PS=3U PD=3U
M$273 \$5.CK2 \$I42 GND_VCO|VSS GND_VCO|VSS nfet_03v3 L=0.28U W=2U AS=1P AD=1P
+ PS=5U PD=5U
M$274 \$I54 \$I51 GND_VCO|VSS GND_VCO|VSS nfet_03v3 L=0.28U W=2U AS=1P AD=1P
+ PS=5U PD=5U
M$275 \$I55 \$I53 GND_VCO|VSS GND_VCO|VSS nfet_03v3 L=0.28U W=1U AS=0.5P
+ AD=0.5P PS=3U PD=3U
M$276 \$I56 \$5.CK1 GND_VCO|VSS GND_VCO|VSS nfet_03v3 L=0.28U W=1U AS=0.5P
+ AD=0.5P PS=3U PD=3U
M$277 \$I57 \$I56 GND_VCO|VSS GND_VCO|VSS nfet_03v3 L=0.28U W=1U AS=0.5P
+ AD=0.5P PS=3U PD=3U
M$278 \$I58 \$I56 \$I55 GND_VCO|VSS nfet_03v3 L=0.28U W=1U AS=0.5P AD=0.5P
+ PS=3U PD=3U
M$279 \$I59 \$I58 GND_VCO|VSS GND_VCO|VSS nfet_03v3 L=0.28U W=1U AS=0.5P
+ AD=0.5P PS=3U PD=3U
M$280 \$I60 \$I59 GND_VCO|VSS GND_VCO|VSS nfet_03v3 L=0.28U W=1U AS=0.5P
+ AD=0.5P PS=3U PD=3U
M$281 \$I58 \$I57 \$I60 GND_VCO|VSS nfet_03v3 L=0.28U W=1U AS=0.5P AD=0.5P
+ PS=3U PD=3U
M$282 \$I61 \$I57 \$I59 GND_VCO|VSS nfet_03v3 L=0.28U W=1U AS=0.5P AD=0.5P
+ PS=3U PD=3U
M$283 \$5.MO1 \$I61 GND_VCO|VSS GND_VCO|VSS nfet_03v3 L=0.28U W=1U AS=0.5P
+ AD=0.5P PS=3U PD=3U
M$284 \$I62 \$5.MO1 GND_VCO|VSS GND_VCO|VSS nfet_03v3 L=0.28U W=1U AS=0.5P
+ AD=0.5P PS=3U PD=3U
M$285 \$I61 \$I56 \$I62 GND_VCO|VSS nfet_03v3 L=0.28U W=1U AS=0.5P AD=0.5P
+ PS=3U PD=3U
M$286 \$5.NMI1 \$5.MO2 GND_VCO|VSS GND_VCO|VSS nfet_03v3 L=0.28U W=1U AS=0.5P
+ AD=0.5P PS=3U PD=3U
M$287 \$5.NMI1 SEL1 GND_VCO|VSS GND_VCO|VSS nfet_03v3 L=0.28U W=1U AS=0.5P
+ AD=0.5P PS=3U PD=3U
M$288 \$5.MI1 \$5.NMI1 GND_VCO|VSS GND_VCO|VSS nfet_03v3 L=0.28U W=1U AS=0.5P
+ AD=0.5P PS=3U PD=3U
M$289 \$5.XM1_NMID SEL1 GND_VCO|VSS GND_VCO|VSS nfet_03v3 L=0.28U W=2U AS=1P
+ AD=1P PS=5U PD=5U
M$290 \$I64 \$5.MO2 GND_VCO|VSS GND_VCO|VSS nfet_03v3 L=0.28U W=3U AS=1.5P
+ AD=1.5P PS=7U PD=7U
M$291 \$I67 \$I95 GND_VCO|VSS GND_VCO|VSS nfet_03v3 L=0.28U W=2U AS=1P AD=1P
+ PS=5U PD=5U
M$292 \$I69 \$I68 GND_VCO|VSS GND_VCO|VSS nfet_03v3 L=0.28U W=1U AS=0.5P
+ AD=0.5P PS=3U PD=3U
M$293 \$I70 \$5.CK2 GND_VCO|VSS GND_VCO|VSS nfet_03v3 L=0.28U W=1U AS=0.5P
+ AD=0.5P PS=3U PD=3U
M$294 \$I71 \$I70 GND_VCO|VSS GND_VCO|VSS nfet_03v3 L=0.28U W=1U AS=0.5P
+ AD=0.5P PS=3U PD=3U
M$295 \$I72 \$I70 \$I69 GND_VCO|VSS nfet_03v3 L=0.28U W=1U AS=0.5P AD=0.5P
+ PS=3U PD=3U
M$296 \$I73 \$I72 GND_VCO|VSS GND_VCO|VSS nfet_03v3 L=0.28U W=1U AS=0.5P
+ AD=0.5P PS=3U PD=3U
M$297 \$I74 \$I73 GND_VCO|VSS GND_VCO|VSS nfet_03v3 L=0.28U W=1U AS=0.5P
+ AD=0.5P PS=3U PD=3U
M$298 \$I72 \$I71 \$I74 GND_VCO|VSS nfet_03v3 L=0.28U W=1U AS=0.5P AD=0.5P
+ PS=3U PD=3U
M$299 \$I75 \$I71 \$I73 GND_VCO|VSS nfet_03v3 L=0.28U W=1U AS=0.5P AD=0.5P
+ PS=3U PD=3U
M$300 \$I76 \$I75 GND_VCO|VSS GND_VCO|VSS nfet_03v3 L=0.28U W=1U AS=0.5P
+ AD=0.5P PS=3U PD=3U
M$301 \$I66 \$I76 GND_VCO|VSS GND_VCO|VSS nfet_03v3 L=0.28U W=1U AS=0.5P
+ AD=0.5P PS=3U PD=3U
M$302 \$I75 \$I70 \$I66 GND_VCO|VSS nfet_03v3 L=0.28U W=1U AS=0.5P AD=0.5P
+ PS=3U PD=3U
M$303 \$5.CK3 \$I66 GND_VCO|VSS GND_VCO|VSS nfet_03v3 L=0.28U W=2U AS=1P AD=1P
+ PS=5U PD=5U
M$304 \$I78 \$I76 GND_VCO|VSS GND_VCO|VSS nfet_03v3 L=0.28U W=2U AS=1P AD=1P
+ PS=5U PD=5U
M$305 \$I80 \$I79 GND_VCO|VSS GND_VCO|VSS nfet_03v3 L=0.28U W=1U AS=0.5P
+ AD=0.5P PS=3U PD=3U
M$306 \$I81 \$5.CK2 GND_VCO|VSS GND_VCO|VSS nfet_03v3 L=0.28U W=1U AS=0.5P
+ AD=0.5P PS=3U PD=3U
M$307 \$I82 \$I81 GND_VCO|VSS GND_VCO|VSS nfet_03v3 L=0.28U W=1U AS=0.5P
+ AD=0.5P PS=3U PD=3U
M$308 \$I83 \$I81 \$I80 GND_VCO|VSS nfet_03v3 L=0.28U W=1U AS=0.5P AD=0.5P
+ PS=3U PD=3U
M$309 \$I84 \$I83 GND_VCO|VSS GND_VCO|VSS nfet_03v3 L=0.28U W=1U AS=0.5P
+ AD=0.5P PS=3U PD=3U
M$310 \$I85 \$I84 GND_VCO|VSS GND_VCO|VSS nfet_03v3 L=0.28U W=1U AS=0.5P
+ AD=0.5P PS=3U PD=3U
M$311 \$I83 \$I82 \$I85 GND_VCO|VSS nfet_03v3 L=0.28U W=1U AS=0.5P AD=0.5P
+ PS=3U PD=3U
M$312 \$I86 \$I82 \$I84 GND_VCO|VSS nfet_03v3 L=0.28U W=1U AS=0.5P AD=0.5P
+ PS=3U PD=3U
M$313 \$5.MO2 \$I86 GND_VCO|VSS GND_VCO|VSS nfet_03v3 L=0.28U W=1U AS=0.5P
+ AD=0.5P PS=3U PD=3U
M$314 \$I87 \$5.MO2 GND_VCO|VSS GND_VCO|VSS nfet_03v3 L=0.28U W=1U AS=0.5P
+ AD=0.5P PS=3U PD=3U
M$315 \$I86 \$I81 \$I87 GND_VCO|VSS nfet_03v3 L=0.28U W=1U AS=0.5P AD=0.5P
+ PS=3U PD=3U
M$316 \$5.NMI2 \$5.MO3 GND_VCO|VSS GND_VCO|VSS nfet_03v3 L=0.28U W=1U AS=0.5P
+ AD=0.5P PS=3U PD=3U
M$317 \$5.NMI2 SEL2 GND_VCO|VSS GND_VCO|VSS nfet_03v3 L=0.28U W=1U AS=0.5P
+ AD=0.5P PS=3U PD=3U
M$318 \$5.MI2 \$5.NMI2 GND_VCO|VSS GND_VCO|VSS nfet_03v3 L=0.28U W=1U AS=0.5P
+ AD=0.5P PS=3U PD=3U
M$319 \$5.XM2_NMID SEL2 GND_VCO|VSS GND_VCO|VSS nfet_03v3 L=0.28U W=2U AS=1P
+ AD=1P PS=5U PD=5U
M$320 \$5.XMA_NM2 \$5.T2 GND_VCO|VSS GND_VCO|VSS nfet_03v3 L=0.28U W=3U AS=1.5P
+ AD=1.5P PS=7U PD=7U
M$321 \$I16 P0 \$I17 GND_VCO|VSS nfet_03v3 L=0.28U W=3U AS=1.5P AD=1.5P PS=7U
+ PD=7U
M$322 \$I91 \$5.MI0 \$I16 GND_VCO|VSS nfet_03v3 L=0.28U W=3U AS=1.5P AD=1.5P
+ PS=7U PD=7U
M$323 \$I19 \$I18 \$I20 GND_VCO|VSS nfet_03v3 L=0.28U W=2U AS=1P AD=1P PS=5U
+ PD=5U
M$324 \$I30 \$5.MI0 \$I29 GND_VCO|VSS nfet_03v3 L=0.28U W=2U AS=1P AD=1P PS=5U
+ PD=5U
M$325 \$5.T0 \$5.CK1 \$5.XM0_NMID GND_VCO|VSS nfet_03v3 L=0.28U W=2U AS=1P
+ AD=1P PS=5U PD=5U
M$326 \$I93 \$5.MI1 \$I41 GND_VCO|VSS nfet_03v3 L=0.28U W=3U AS=1.5P AD=1.5P
+ PS=7U PD=7U
M$327 \$I41 P1 \$I40 GND_VCO|VSS nfet_03v3 L=0.28U W=3U AS=1.5P AD=1.5P PS=7U
+ PD=7U
M$328 \$I43 \$I42 \$I44 GND_VCO|VSS nfet_03v3 L=0.28U W=2U AS=1P AD=1P PS=5U
+ PD=5U
M$329 \$I53 \$5.MI1 \$I54 GND_VCO|VSS nfet_03v3 L=0.28U W=2U AS=1P AD=1P PS=5U
+ PD=5U
M$330 \$5.T1 \$5.CK2 \$5.XM1_NMID GND_VCO|VSS nfet_03v3 L=0.28U W=2U AS=1P
+ AD=1P PS=5U PD=5U
M$331 \$I95 \$5.MI2 \$I65 GND_VCO|VSS nfet_03v3 L=0.28U W=3U AS=1.5P AD=1.5P
+ PS=7U PD=7U
M$332 \$I65 P2 \$I64 GND_VCO|VSS nfet_03v3 L=0.28U W=3U AS=1.5P AD=1.5P PS=7U
+ PD=7U
M$333 \$I68 \$I66 \$I67 GND_VCO|VSS nfet_03v3 L=0.28U W=2U AS=1P AD=1P PS=5U
+ PD=5U
M$334 \$I79 \$5.MI2 \$I78 GND_VCO|VSS nfet_03v3 L=0.28U W=2U AS=1P AD=1P PS=5U
+ PD=5U
M$335 \$5.T2 \$5.CK3 \$5.XM2_NMID GND_VCO|VSS nfet_03v3 L=0.28U W=2U AS=1P
+ AD=1P PS=5U PD=5U
M$336 \$5.MA \$5.T0 \$5.XMA_NM1 GND_VCO|VSS nfet_03v3 L=0.28U W=3U AS=1.5P
+ AD=1.5P PS=7U PD=7U
M$337 \$5.XMA_NM1 \$5.T1 \$5.XMA_NM2 GND_VCO|VSS nfet_03v3 L=0.28U W=3U AS=1.5P
+ AD=1.5P PS=7U PD=7U
M$338 \$5.XFRT_CKB CLK GND_VCO|VSS GND_VCO|VSS nfet_03v3 L=0.28U W=1U AS=0.5P
+ AD=0.5P PS=3U PD=3U
M$339 \$5.XFRT_CKBB \$5.XFRT_CKB GND_VCO|VSS GND_VCO|VSS nfet_03v3 L=0.28U W=1U
+ AS=0.5P AD=0.5P PS=3U PD=3U
M$340 \$5.XFRT_NM \$5.XFRT_CKB DIVOUT GND_VCO|VSS nfet_03v3 L=0.28U W=1U
+ AS=0.5P AD=0.5P PS=3U PD=3U
M$341 \$5.XFRT_NMA \$5.XFRT_NM GND_VCO|VSS GND_VCO|VSS nfet_03v3 L=0.28U W=1U
+ AS=0.5P AD=0.5P PS=3U PD=3U
M$342 \$5.XFRT_NMB \$5.XFRT_NMA GND_VCO|VSS GND_VCO|VSS nfet_03v3 L=0.28U W=1U
+ AS=0.5P AD=0.5P PS=3U PD=3U
M$343 \$5.XFRT_NM \$5.XFRT_CKBB \$5.XFRT_NMB GND_VCO|VSS nfet_03v3 L=0.28U W=1U
+ AS=0.5P AD=0.5P PS=3U PD=3U
M$344 \$5.XFRT_NS \$5.XFRT_CKBB \$5.XFRT_NMA GND_VCO|VSS nfet_03v3 L=0.28U W=1U
+ AS=0.5P AD=0.5P PS=3U PD=3U
M$345 FB \$5.XFRT_NS GND_VCO|VSS GND_VCO|VSS nfet_03v3 L=0.28U W=1U AS=0.5P
+ AD=0.5P PS=3U PD=3U
M$346 \$5.FBB FB GND_VCO|VSS GND_VCO|VSS nfet_03v3 L=0.28U W=1U AS=0.5P AD=0.5P
+ PS=3U PD=3U
M$347 \$5.XFRT_NS \$5.XFRT_CKB \$5.FBB GND_VCO|VSS nfet_03v3 L=0.28U W=1U
+ AS=0.5P AD=0.5P PS=3U PD=3U
M$348 \$I112 \$5.MO3 GND_VCO|VSS GND_VCO|VSS nfet_03v3 L=0.28U W=3U AS=1.5P
+ AD=1.5P PS=7U PD=7U
M$349 \$I114 \$I195 GND_VCO|VSS GND_VCO|VSS nfet_03v3 L=0.28U W=2U AS=1P AD=1P
+ PS=5U PD=5U
M$350 \$I115 \$I182 GND_VCO|VSS GND_VCO|VSS nfet_03v3 L=0.28U W=1U AS=0.5P
+ AD=0.5P PS=3U PD=3U
M$351 \$I116 \$5.CK3 GND_VCO|VSS GND_VCO|VSS nfet_03v3 L=0.28U W=1U AS=0.5P
+ AD=0.5P PS=3U PD=3U
M$352 \$I117 \$I116 GND_VCO|VSS GND_VCO|VSS nfet_03v3 L=0.28U W=1U AS=0.5P
+ AD=0.5P PS=3U PD=3U
M$353 \$I118 \$I116 \$I115 GND_VCO|VSS nfet_03v3 L=0.28U W=1U AS=0.5P AD=0.5P
+ PS=3U PD=3U
M$354 \$I119 \$I118 GND_VCO|VSS GND_VCO|VSS nfet_03v3 L=0.28U W=1U AS=0.5P
+ AD=0.5P PS=3U PD=3U
M$355 \$I120 \$I119 GND_VCO|VSS GND_VCO|VSS nfet_03v3 L=0.28U W=1U AS=0.5P
+ AD=0.5P PS=3U PD=3U
M$356 \$I118 \$I117 \$I120 GND_VCO|VSS nfet_03v3 L=0.28U W=1U AS=0.5P AD=0.5P
+ PS=3U PD=3U
M$357 \$I121 \$I117 \$I119 GND_VCO|VSS nfet_03v3 L=0.28U W=1U AS=0.5P AD=0.5P
+ PS=3U PD=3U
M$358 \$I122 \$I121 GND_VCO|VSS GND_VCO|VSS nfet_03v3 L=0.28U W=1U AS=0.5P
+ AD=0.5P PS=3U PD=3U
M$359 \$I113 \$I122 GND_VCO|VSS GND_VCO|VSS nfet_03v3 L=0.28U W=1U AS=0.5P
+ AD=0.5P PS=3U PD=3U
M$360 \$I121 \$I116 \$I113 GND_VCO|VSS nfet_03v3 L=0.28U W=1U AS=0.5P AD=0.5P
+ PS=3U PD=3U
M$361 \$5.CK4 \$I113 GND_VCO|VSS GND_VCO|VSS nfet_03v3 L=0.28U W=2U AS=1P AD=1P
+ PS=5U PD=5U
M$362 \$I124 \$I122 GND_VCO|VSS GND_VCO|VSS nfet_03v3 L=0.28U W=2U AS=1P AD=1P
+ PS=5U PD=5U
M$363 \$I125 \$I183 GND_VCO|VSS GND_VCO|VSS nfet_03v3 L=0.28U W=1U AS=0.5P
+ AD=0.5P PS=3U PD=3U
M$364 \$I126 \$5.CK3 GND_VCO|VSS GND_VCO|VSS nfet_03v3 L=0.28U W=1U AS=0.5P
+ AD=0.5P PS=3U PD=3U
M$365 \$I127 \$I126 GND_VCO|VSS GND_VCO|VSS nfet_03v3 L=0.28U W=1U AS=0.5P
+ AD=0.5P PS=3U PD=3U
M$366 \$I128 \$I126 \$I125 GND_VCO|VSS nfet_03v3 L=0.28U W=1U AS=0.5P AD=0.5P
+ PS=3U PD=3U
M$367 \$I129 \$I128 GND_VCO|VSS GND_VCO|VSS nfet_03v3 L=0.28U W=1U AS=0.5P
+ AD=0.5P PS=3U PD=3U
M$368 \$I130 \$I129 GND_VCO|VSS GND_VCO|VSS nfet_03v3 L=0.28U W=1U AS=0.5P
+ AD=0.5P PS=3U PD=3U
M$369 \$I128 \$I127 \$I130 GND_VCO|VSS nfet_03v3 L=0.28U W=1U AS=0.5P AD=0.5P
+ PS=3U PD=3U
M$370 \$I131 \$I127 \$I129 GND_VCO|VSS nfet_03v3 L=0.28U W=1U AS=0.5P AD=0.5P
+ PS=3U PD=3U
M$371 \$5.MO3 \$I131 GND_VCO|VSS GND_VCO|VSS nfet_03v3 L=0.28U W=1U AS=0.5P
+ AD=0.5P PS=3U PD=3U
M$372 \$I132 \$5.MO3 GND_VCO|VSS GND_VCO|VSS nfet_03v3 L=0.28U W=1U AS=0.5P
+ AD=0.5P PS=3U PD=3U
M$373 \$I131 \$I126 \$I132 GND_VCO|VSS nfet_03v3 L=0.28U W=1U AS=0.5P AD=0.5P
+ PS=3U PD=3U
M$374 \$5.NMI3 \$5.MO4 GND_VCO|VSS GND_VCO|VSS nfet_03v3 L=0.28U W=1U AS=0.5P
+ AD=0.5P PS=3U PD=3U
M$375 \$5.NMI3 SEL3 GND_VCO|VSS GND_VCO|VSS nfet_03v3 L=0.28U W=1U AS=0.5P
+ AD=0.5P PS=3U PD=3U
M$376 \$5.MI3 \$5.NMI3 GND_VCO|VSS GND_VCO|VSS nfet_03v3 L=0.28U W=1U AS=0.5P
+ AD=0.5P PS=3U PD=3U
M$377 \$5.XM3_NMID SEL3 GND_VCO|VSS GND_VCO|VSS nfet_03v3 L=0.28U W=2U AS=1P
+ AD=1P PS=5U PD=5U
M$378 \$I136 \$5.MO4 GND_VCO|VSS GND_VCO|VSS nfet_03v3 L=0.28U W=3U AS=1.5P
+ AD=1.5P PS=7U PD=7U
M$379 \$I138 \$I196 GND_VCO|VSS GND_VCO|VSS nfet_03v3 L=0.28U W=2U AS=1P AD=1P
+ PS=5U PD=5U
M$380 \$I139 \$I187 GND_VCO|VSS GND_VCO|VSS nfet_03v3 L=0.28U W=1U AS=0.5P
+ AD=0.5P PS=3U PD=3U
M$381 \$I140 \$5.CK4 GND_VCO|VSS GND_VCO|VSS nfet_03v3 L=0.28U W=1U AS=0.5P
+ AD=0.5P PS=3U PD=3U
M$382 \$I141 \$I140 GND_VCO|VSS GND_VCO|VSS nfet_03v3 L=0.28U W=1U AS=0.5P
+ AD=0.5P PS=3U PD=3U
M$383 \$I142 \$I140 \$I139 GND_VCO|VSS nfet_03v3 L=0.28U W=1U AS=0.5P AD=0.5P
+ PS=3U PD=3U
M$384 \$I143 \$I142 GND_VCO|VSS GND_VCO|VSS nfet_03v3 L=0.28U W=1U AS=0.5P
+ AD=0.5P PS=3U PD=3U
M$385 \$I144 \$I143 GND_VCO|VSS GND_VCO|VSS nfet_03v3 L=0.28U W=1U AS=0.5P
+ AD=0.5P PS=3U PD=3U
M$386 \$I142 \$I141 \$I144 GND_VCO|VSS nfet_03v3 L=0.28U W=1U AS=0.5P AD=0.5P
+ PS=3U PD=3U
M$387 \$I145 \$I141 \$I143 GND_VCO|VSS nfet_03v3 L=0.28U W=1U AS=0.5P AD=0.5P
+ PS=3U PD=3U
M$388 \$I146 \$I145 GND_VCO|VSS GND_VCO|VSS nfet_03v3 L=0.28U W=1U AS=0.5P
+ AD=0.5P PS=3U PD=3U
M$389 \$I137 \$I146 GND_VCO|VSS GND_VCO|VSS nfet_03v3 L=0.28U W=1U AS=0.5P
+ AD=0.5P PS=3U PD=3U
M$390 \$I145 \$I140 \$I137 GND_VCO|VSS nfet_03v3 L=0.28U W=1U AS=0.5P AD=0.5P
+ PS=3U PD=3U
M$391 \$5.CK5 \$I137 GND_VCO|VSS GND_VCO|VSS nfet_03v3 L=0.28U W=2U AS=1P AD=1P
+ PS=5U PD=5U
M$392 \$I147 \$I146 GND_VCO|VSS GND_VCO|VSS nfet_03v3 L=0.28U W=2U AS=1P AD=1P
+ PS=5U PD=5U
M$393 \$I148 \$I188 GND_VCO|VSS GND_VCO|VSS nfet_03v3 L=0.28U W=1U AS=0.5P
+ AD=0.5P PS=3U PD=3U
M$394 \$I149 \$5.CK4 GND_VCO|VSS GND_VCO|VSS nfet_03v3 L=0.28U W=1U AS=0.5P
+ AD=0.5P PS=3U PD=3U
M$395 \$I150 \$I149 GND_VCO|VSS GND_VCO|VSS nfet_03v3 L=0.28U W=1U AS=0.5P
+ AD=0.5P PS=3U PD=3U
M$396 \$I151 \$I149 \$I148 GND_VCO|VSS nfet_03v3 L=0.28U W=1U AS=0.5P AD=0.5P
+ PS=3U PD=3U
M$397 \$I152 \$I151 GND_VCO|VSS GND_VCO|VSS nfet_03v3 L=0.28U W=1U AS=0.5P
+ AD=0.5P PS=3U PD=3U
M$398 \$I153 \$I152 GND_VCO|VSS GND_VCO|VSS nfet_03v3 L=0.28U W=1U AS=0.5P
+ AD=0.5P PS=3U PD=3U
M$399 \$I151 \$I150 \$I153 GND_VCO|VSS nfet_03v3 L=0.28U W=1U AS=0.5P AD=0.5P
+ PS=3U PD=3U
M$400 \$I154 \$I150 \$I152 GND_VCO|VSS nfet_03v3 L=0.28U W=1U AS=0.5P AD=0.5P
+ PS=3U PD=3U
M$401 \$5.MO4 \$I154 GND_VCO|VSS GND_VCO|VSS nfet_03v3 L=0.28U W=1U AS=0.5P
+ AD=0.5P PS=3U PD=3U
M$402 \$I155 \$5.MO4 GND_VCO|VSS GND_VCO|VSS nfet_03v3 L=0.28U W=1U AS=0.5P
+ AD=0.5P PS=3U PD=3U
M$403 \$I154 \$I149 \$I155 GND_VCO|VSS nfet_03v3 L=0.28U W=1U AS=0.5P AD=0.5P
+ PS=3U PD=3U
M$404 \$5.NMI4 \$5.MO5 GND_VCO|VSS GND_VCO|VSS nfet_03v3 L=0.28U W=1U AS=0.5P
+ AD=0.5P PS=3U PD=3U
M$405 \$5.NMI4 SEL4 GND_VCO|VSS GND_VCO|VSS nfet_03v3 L=0.28U W=1U AS=0.5P
+ AD=0.5P PS=3U PD=3U
M$406 \$5.MI4 \$5.NMI4 GND_VCO|VSS GND_VCO|VSS nfet_03v3 L=0.28U W=1U AS=0.5P
+ AD=0.5P PS=3U PD=3U
M$407 \$5.XM4_NMID SEL4 GND_VCO|VSS GND_VCO|VSS nfet_03v3 L=0.28U W=2U AS=1P
+ AD=1P PS=5U PD=5U
M$408 \$I101 \$5.MO5 GND_VCO|VSS GND_VCO|VSS nfet_03v3 L=0.28U W=3U AS=1.5P
+ AD=1.5P PS=7U PD=7U
M$409 \$I159 \$I197 GND_VCO|VSS GND_VCO|VSS nfet_03v3 L=0.28U W=2U AS=1P AD=1P
+ PS=5U PD=5U
M$410 \$I160 \$I191 GND_VCO|VSS GND_VCO|VSS nfet_03v3 L=0.28U W=1U AS=0.5P
+ AD=0.5P PS=3U PD=3U
M$411 \$I161 \$5.CK5 GND_VCO|VSS GND_VCO|VSS nfet_03v3 L=0.28U W=1U AS=0.5P
+ AD=0.5P PS=3U PD=3U
M$412 \$I162 \$I161 GND_VCO|VSS GND_VCO|VSS nfet_03v3 L=0.28U W=1U AS=0.5P
+ AD=0.5P PS=3U PD=3U
M$413 \$I163 \$I161 \$I160 GND_VCO|VSS nfet_03v3 L=0.28U W=1U AS=0.5P AD=0.5P
+ PS=3U PD=3U
M$414 \$I164 \$I163 GND_VCO|VSS GND_VCO|VSS nfet_03v3 L=0.28U W=1U AS=0.5P
+ AD=0.5P PS=3U PD=3U
M$415 \$I165 \$I164 GND_VCO|VSS GND_VCO|VSS nfet_03v3 L=0.28U W=1U AS=0.5P
+ AD=0.5P PS=3U PD=3U
M$416 \$I163 \$I162 \$I165 GND_VCO|VSS nfet_03v3 L=0.28U W=1U AS=0.5P AD=0.5P
+ PS=3U PD=3U
M$417 \$I166 \$I162 \$I164 GND_VCO|VSS nfet_03v3 L=0.28U W=1U AS=0.5P AD=0.5P
+ PS=3U PD=3U
M$418 \$I167 \$I166 GND_VCO|VSS GND_VCO|VSS nfet_03v3 L=0.28U W=1U AS=0.5P
+ AD=0.5P PS=3U PD=3U
M$419 \$I158 \$I167 GND_VCO|VSS GND_VCO|VSS nfet_03v3 L=0.28U W=1U AS=0.5P
+ AD=0.5P PS=3U PD=3U
M$420 \$I166 \$I161 \$I158 GND_VCO|VSS nfet_03v3 L=0.28U W=1U AS=0.5P AD=0.5P
+ PS=3U PD=3U
M$421 \$5.CK6 \$I158 GND_VCO|VSS GND_VCO|VSS nfet_03v3 L=0.28U W=2U AS=1P AD=1P
+ PS=5U PD=5U
M$422 \$I169 \$I167 GND_VCO|VSS GND_VCO|VSS nfet_03v3 L=0.28U W=2U AS=1P AD=1P
+ PS=5U PD=5U
M$423 \$I170 \$I192 GND_VCO|VSS GND_VCO|VSS nfet_03v3 L=0.28U W=1U AS=0.5P
+ AD=0.5P PS=3U PD=3U
M$424 \$I171 \$5.CK5 GND_VCO|VSS GND_VCO|VSS nfet_03v3 L=0.28U W=1U AS=0.5P
+ AD=0.5P PS=3U PD=3U
M$425 \$I172 \$I171 GND_VCO|VSS GND_VCO|VSS nfet_03v3 L=0.28U W=1U AS=0.5P
+ AD=0.5P PS=3U PD=3U
M$426 \$I173 \$I171 \$I170 GND_VCO|VSS nfet_03v3 L=0.28U W=1U AS=0.5P AD=0.5P
+ PS=3U PD=3U
M$427 \$I174 \$I173 GND_VCO|VSS GND_VCO|VSS nfet_03v3 L=0.28U W=1U AS=0.5P
+ AD=0.5P PS=3U PD=3U
M$428 \$I175 \$I174 GND_VCO|VSS GND_VCO|VSS nfet_03v3 L=0.28U W=1U AS=0.5P
+ AD=0.5P PS=3U PD=3U
M$429 \$I173 \$I172 \$I175 GND_VCO|VSS nfet_03v3 L=0.28U W=1U AS=0.5P AD=0.5P
+ PS=3U PD=3U
M$430 \$I176 \$I172 \$I174 GND_VCO|VSS nfet_03v3 L=0.28U W=1U AS=0.5P AD=0.5P
+ PS=3U PD=3U
M$431 \$5.MO5 \$I176 GND_VCO|VSS GND_VCO|VSS nfet_03v3 L=0.28U W=1U AS=0.5P
+ AD=0.5P PS=3U PD=3U
M$432 \$I177 \$5.MO5 GND_VCO|VSS GND_VCO|VSS nfet_03v3 L=0.28U W=1U AS=0.5P
+ AD=0.5P PS=3U PD=3U
M$433 \$I176 \$I171 \$I177 GND_VCO|VSS nfet_03v3 L=0.28U W=1U AS=0.5P AD=0.5P
+ PS=3U PD=3U
M$434 \$5.XM5_NMID SEL5 GND_VCO|VSS GND_VCO|VSS nfet_03v3 L=0.28U W=2U AS=1P
+ AD=1P PS=5U PD=5U
M$435 \$5.XMB_NM2 \$5.T5 GND_VCO|VSS GND_VCO|VSS nfet_03v3 L=0.28U W=3U AS=1.5P
+ AD=1.5P PS=7U PD=7U
M$436 \$I181 P3 \$I112 GND_VCO|VSS nfet_03v3 L=0.28U W=3U AS=1.5P AD=1.5P PS=7U
+ PD=7U
M$437 \$I195 \$5.MI3 \$I181 GND_VCO|VSS nfet_03v3 L=0.28U W=3U AS=1.5P AD=1.5P
+ PS=7U PD=7U
M$438 \$I182 \$I113 \$I114 GND_VCO|VSS nfet_03v3 L=0.28U W=2U AS=1P AD=1P PS=5U
+ PD=5U
M$439 \$I183 \$5.MI3 \$I124 GND_VCO|VSS nfet_03v3 L=0.28U W=2U AS=1P AD=1P
+ PS=5U PD=5U
M$440 \$5.T3 \$5.CK4 \$5.XM3_NMID GND_VCO|VSS nfet_03v3 L=0.28U W=2U AS=1P
+ AD=1P PS=5U PD=5U
M$441 \$I186 P4 \$I136 GND_VCO|VSS nfet_03v3 L=0.28U W=3U AS=1.5P AD=1.5P PS=7U
+ PD=7U
M$442 \$I196 \$5.MI4 \$I186 GND_VCO|VSS nfet_03v3 L=0.28U W=3U AS=1.5P AD=1.5P
+ PS=7U PD=7U
M$443 \$I187 \$I137 \$I138 GND_VCO|VSS nfet_03v3 L=0.28U W=2U AS=1P AD=1P PS=5U
+ PD=5U
M$444 \$I188 \$5.MI4 \$I147 GND_VCO|VSS nfet_03v3 L=0.28U W=2U AS=1P AD=1P
+ PS=5U PD=5U
M$445 \$5.T4 \$5.CK5 \$5.XM4_NMID GND_VCO|VSS nfet_03v3 L=0.28U W=2U AS=1P
+ AD=1P PS=5U PD=5U
M$446 \$I197 SEL5 \$I190 GND_VCO|VSS nfet_03v3 L=0.28U W=3U AS=1.5P AD=1.5P
+ PS=7U PD=7U
M$447 \$I190 P5 \$I101 GND_VCO|VSS nfet_03v3 L=0.28U W=3U AS=1.5P AD=1.5P PS=7U
+ PD=7U
M$448 \$I191 \$I158 \$I159 GND_VCO|VSS nfet_03v3 L=0.28U W=2U AS=1P AD=1P PS=5U
+ PD=5U
M$449 \$I192 SEL5 \$I169 GND_VCO|VSS nfet_03v3 L=0.28U W=2U AS=1P AD=1P PS=5U
+ PD=5U
M$450 \$5.T5 \$5.CK6 \$5.XM5_NMID GND_VCO|VSS nfet_03v3 L=0.28U W=2U AS=1P
+ AD=1P PS=5U PD=5U
M$451 \$5.XMB_NM1 \$5.T4 \$5.XMB_NM2 GND_VCO|VSS nfet_03v3 L=0.28U W=3U AS=1.5P
+ AD=1.5P PS=7U PD=7U
M$452 \$5.MB \$5.T3 \$5.XMB_NM1 GND_VCO|VSS nfet_03v3 L=0.28U W=3U AS=1.5P
+ AD=1.5P PS=7U PD=7U
M$453 VDD_VCO GND_VCO|VSS \$I205 VDD_VCO pfet_03v3 L=20U W=0.22U AS=0.53P
+ AD=0.53P PS=3.84U PD=3.84U
M$454 VDD_VCO \$I204 \$I207 VDD_VCO pfet_03v3 L=1U W=10U AS=15P AD=15P PS=23U
+ PD=23U
M$455 VDD_VCO \$I204 \$I204 VDD_VCO pfet_03v3 L=1U W=10U AS=15P AD=15P PS=23U
+ PD=23U
M$456 VDD_VCO \$I204 \$I203 VDD_VCO pfet_03v3 L=1U W=2.5U AS=3.75P AD=3.75P
+ PS=8U PD=8U
M$457 VDD_VCO \$3.VBP0 \$3.VBP0 VDD_VCO pfet_03v3 L=1U W=15U AS=22.5P AD=22.5P
+ PS=33U PD=33U
M$458 VDD_VCO \$3.VBP0 \$3.VBP0 VDD_VCO pfet_03v3 L=1U W=15U AS=22.5P AD=22.5P
+ PS=33U PD=33U
M$459 VDD_VCO \$3.VBP0 \$3.VBP0 VDD_VCO pfet_03v3 L=1U W=15U AS=22.5P AD=22.5P
+ PS=33U PD=33U
M$460 VDD_VCO \$3.VBP0 \$3.VBP0 VDD_VCO pfet_03v3 L=1U W=15U AS=22.5P AD=22.5P
+ PS=33U PD=33U
M$461 VDD_VCO \$3.VBP0 \$I211 VDD_VCO pfet_03v3 L=1U W=13.25U AS=19.875P
+ AD=19.875P PS=29.5U PD=29.5U
M$462 VDD_VCO \$I214 \$I211 VDD_VCO pfet_03v3 L=1U W=8.61U AS=12.915P
+ AD=12.915P PS=20.22U PD=20.22U
M$463 VDD_VCO B0 \$I210 VDD_VCO pfet_03v3 L=0.28U W=2U AS=3P AD=3P PS=7U PD=7U
M$464 VDD_VCO \$I214 \$I211 VDD_VCO pfet_03v3 L=1U W=8.61U AS=12.915P
+ AD=12.915P PS=20.22U PD=20.22U
M$465 VDD_VCO \$3.VBP0 \$I211 VDD_VCO pfet_03v3 L=1U W=13.25U AS=19.875P
+ AD=19.875P PS=29.5U PD=29.5U
M$466 \$3.VBP0 \$I210 \$I214 VDD_VCO pfet_03v3 L=0.5U W=2U AS=3P AD=3P PS=7U
+ PD=7U
M$467 VDD_VCO B0 \$I214 VDD_VCO pfet_03v3 L=0.5U W=2U AS=3P AD=3P PS=7U PD=7U
M$468 VDD_VCO B1 \$I209 VDD_VCO pfet_03v3 L=0.28U W=2U AS=3P AD=3P PS=7U PD=7U
M$469 VDD_VCO \$I212 \$I212 VDD_VCO pfet_03v3 L=1U W=20U AS=30P AD=30P PS=43U
+ PD=43U
M$470 VDD_VCO B2 \$I213 VDD_VCO pfet_03v3 L=0.28U W=2U AS=3P AD=3P PS=7U PD=7U
M$471 \$I212 \$I213 \$I215 VDD_VCO pfet_03v3 L=0.5U W=2U AS=3P AD=3P PS=7U PD=7U
M$472 VDD_VCO B2 \$I215 VDD_VCO pfet_03v3 L=0.5U W=2U AS=3P AD=3P PS=7U PD=7U
M$473 VDD_VCO \$I215 \$3.VBN VDD_VCO pfet_03v3 L=1U W=9.86U AS=14.79P AD=14.79P
+ PS=22.72U PD=22.72U
M$474 VDD_VCO \$I215 \$3.VBN VDD_VCO pfet_03v3 L=1U W=9.86U AS=14.79P AD=14.79P
+ PS=22.72U PD=22.72U
M$475 VDD_VCO \$I215 \$3.VBN VDD_VCO pfet_03v3 L=1U W=9.86U AS=14.79P AD=14.79P
+ PS=22.72U PD=22.72U
M$476 VDD_VCO \$I215 \$3.VBN VDD_VCO pfet_03v3 L=1U W=9.86U AS=14.79P AD=14.79P
+ PS=22.72U PD=22.72U
M$477 VDD_VCO \$I212 \$3.VBN VDD_VCO pfet_03v3 L=1U W=12.3U AS=18.45P AD=18.45P
+ PS=27.6U PD=27.6U
M$478 VDD_VCO \$I215 \$3.VBN VDD_VCO pfet_03v3 L=1U W=9.86U AS=14.79P AD=14.79P
+ PS=22.72U PD=22.72U
M$479 VDD_VCO \$I215 \$3.VBN VDD_VCO pfet_03v3 L=1U W=9.86U AS=14.79P AD=14.79P
+ PS=22.72U PD=22.72U
M$480 VDD_VCO \$I215 \$3.VBN VDD_VCO pfet_03v3 L=1U W=9.86U AS=14.79P AD=14.79P
+ PS=22.72U PD=22.72U
M$481 VDD_VCO \$I215 \$3.VBN VDD_VCO pfet_03v3 L=1U W=9.86U AS=14.79P AD=14.79P
+ PS=22.72U PD=22.72U
M$482 VDD_VCO \$3.VBP \$3.VBP VDD_VCO pfet_03v3 L=0.5U W=10U AS=15P AD=15P
+ PS=23U PD=23U
M$483 \$I229 \$3.S5.Y|Y5|Y5_CLK_IN \$3.S1.Y|Y1 VDD_VCO pfet_03v3 L=0.28U W=5U
+ AS=2.5P AD=2.5P PS=11U PD=11U
M$484 \$I230 \$3.S1.Y|Y1 \$3.S2.Y|Y2 VDD_VCO pfet_03v3 L=0.28U W=5U AS=2.5P
+ AD=2.5P PS=11U PD=11U
M$485 \$I231 \$3.S2.Y|Y2 \$3.S3.Y|Y3 VDD_VCO pfet_03v3 L=0.28U W=5U AS=2.5P
+ AD=2.5P PS=11U PD=11U
M$486 \$I232 \$3.S3.Y|Y3 \$3.S4.Y|Y4 VDD_VCO pfet_03v3 L=0.28U W=5U AS=2.5P
+ AD=2.5P PS=11U PD=11U
M$487 \$I233 \$3.S4.Y|Y4 \$3.S5.Y|Y5|Y5_CLK_IN VDD_VCO pfet_03v3 L=0.28U W=5U
+ AS=2.5P AD=2.5P PS=11U PD=11U
M$488 VDD_VCO \$3.VBP \$I229 VDD_VCO pfet_03v3 L=0.5U W=10U AS=5P AD=5P PS=21U
+ PD=21U
M$489 VDD_VCO \$3.VBP \$I230 VDD_VCO pfet_03v3 L=0.5U W=10U AS=5P AD=5P PS=21U
+ PD=21U
M$490 VDD_VCO \$3.VBP \$I231 VDD_VCO pfet_03v3 L=0.5U W=10U AS=5P AD=5P PS=21U
+ PD=21U
M$491 VDD_VCO \$3.VBP \$I232 VDD_VCO pfet_03v3 L=0.5U W=10U AS=5P AD=5P PS=21U
+ PD=21U
M$492 VDD_VCO \$3.VBP \$I233 VDD_VCO pfet_03v3 L=0.5U W=10U AS=5P AD=5P PS=21U
+ PD=21U
M$493 VDD_VCO \$3.S5.Y|Y5|Y5_CLK_IN \$3.NB1 VDD_VCO pfet_03v3 L=0.28U W=1.25U
+ AS=0.625P AD=0.625P PS=3.5U PD=3.5U
M$494 VDD_VCO \$3.NB1 \$3.NB2 VDD_VCO pfet_03v3 L=0.28U W=3.75U AS=1.875P
+ AD=1.875P PS=8.5U PD=8.5U
M$495 VDD_VCO \$3.NB2 CLK VDD_VCO pfet_03v3 L=0.28U W=11.25U AS=5.625P
+ AD=5.625P PS=23.5U PD=23.5U
M$496 \$I207 \$I207 GND_VCO|VSS GND_VCO|VSS nfet_03v3 L=1U W=1.4U AS=2.1P
+ AD=2.1P PS=5.8U PD=5.8U
M$497 \$I204 \$I207 \$3.NC GND_VCO|VSS nfet_03v3 L=1U W=5.6U AS=8.4P AD=8.4P
+ PS=14.2U PD=14.2U
M$498 \$I205 \$I207 GND_VCO|VSS GND_VCO|VSS nfet_03v3 L=1U W=2U AS=3P AD=3P
+ PS=7U PD=7U
M$499 \$I204 \$I205 GND_VCO|VSS GND_VCO|VSS nfet_03v3 L=1U W=1U AS=1.5P AD=1.5P
+ PS=5U PD=5U
M$500 \$I203 \$I203 \$I200 GND_VCO|VSS nfet_03v3 L=1U W=2U AS=3P AD=3P PS=7U
+ PD=7U
M$501 \$I200 \$I200 GND_VCO|VSS GND_VCO|VSS nfet_03v3 L=1U W=2U AS=3P AD=3P
+ PS=7U PD=7U
M$502 \$3.VBP0 \$I203 \$3.NOFF GND_VCO|VSS nfet_03v3 L=1U W=10U AS=15P AD=15P
+ PS=23U PD=23U
M$503 \$3.VBP0 VCTRL \$3.NVI GND_VCO|VSS nfet_03v3 L=1U W=10U AS=15P AD=15P
+ PS=23U PD=23U
M$504 \$I210 B0 GND_VCO|VSS GND_VCO|VSS nfet_03v3 L=0.28U W=1U AS=1.5P AD=1.5P
+ PS=5U PD=5U
M$505 \$I211 \$I211 GND_VCO|VSS GND_VCO|VSS nfet_03v3 L=1U W=10U AS=15P AD=15P
+ PS=23U PD=23U
M$506 \$I212 \$I211 GND_VCO|VSS GND_VCO|VSS nfet_03v3 L=1U W=2.5U AS=3.75P
+ AD=3.75P PS=8U PD=8U
M$507 \$I212 \$I208 GND_VCO|VSS GND_VCO|VSS nfet_03v3 L=1U W=4.305U AS=6.4575P
+ AD=6.4575P PS=11.61U PD=11.61U
M$508 \$I212 \$I208 GND_VCO|VSS GND_VCO|VSS nfet_03v3 L=1U W=4.305U AS=6.4575P
+ AD=6.4575P PS=11.61U PD=11.61U
M$509 \$I212 \$I211 GND_VCO|VSS GND_VCO|VSS nfet_03v3 L=1U W=2.5U AS=3.75P
+ AD=3.75P PS=8U PD=8U
M$510 \$I208 B1 \$I211 GND_VCO|VSS nfet_03v3 L=0.5U W=2U AS=3P AD=3P PS=7U PD=7U
M$511 \$I208 \$I209 GND_VCO|VSS GND_VCO|VSS nfet_03v3 L=0.5U W=2U AS=3P AD=3P
+ PS=7U PD=7U
M$512 \$I209 B1 GND_VCO|VSS GND_VCO|VSS nfet_03v3 L=0.28U W=1U AS=1.5P AD=1.5P
+ PS=5U PD=5U
M$513 \$I213 B2 GND_VCO|VSS GND_VCO|VSS nfet_03v3 L=0.28U W=1U AS=1.5P AD=1.5P
+ PS=5U PD=5U
M$514 \$3.VBN \$3.VBN GND_VCO|VSS GND_VCO|VSS nfet_03v3 L=0.5U W=4U AS=6P AD=6P
+ PS=11U PD=11U
M$515 \$3.VBP \$3.VBN GND_VCO|VSS GND_VCO|VSS nfet_03v3 L=0.5U W=4U AS=6P AD=6P
+ PS=11U PD=11U
M$516 \$I220 \$3.VBN GND_VCO|VSS GND_VCO|VSS nfet_03v3 L=0.5U W=4U AS=2P AD=2P
+ PS=9U PD=9U
M$517 \$I221 \$3.VBN GND_VCO|VSS GND_VCO|VSS nfet_03v3 L=0.5U W=4U AS=2P AD=2P
+ PS=9U PD=9U
M$518 \$I222 \$3.VBN GND_VCO|VSS GND_VCO|VSS nfet_03v3 L=0.5U W=4U AS=2P AD=2P
+ PS=9U PD=9U
M$519 \$I223 \$3.VBN GND_VCO|VSS GND_VCO|VSS nfet_03v3 L=0.5U W=4U AS=2P AD=2P
+ PS=9U PD=9U
M$520 \$I224 \$3.VBN GND_VCO|VSS GND_VCO|VSS nfet_03v3 L=0.5U W=4U AS=2P AD=2P
+ PS=9U PD=9U
M$521 \$3.S1.Y|Y1 \$3.S5.Y|Y5|Y5_CLK_IN \$I220 GND_VCO|VSS nfet_03v3 L=0.28U
+ W=2U AS=1P AD=1P PS=5U PD=5U
M$522 \$3.S2.Y|Y2 \$3.S1.Y|Y1 \$I221 GND_VCO|VSS nfet_03v3 L=0.28U W=2U AS=1P
+ AD=1P PS=5U PD=5U
M$523 \$3.S3.Y|Y3 \$3.S2.Y|Y2 \$I222 GND_VCO|VSS nfet_03v3 L=0.28U W=2U AS=1P
+ AD=1P PS=5U PD=5U
M$524 \$3.S4.Y|Y4 \$3.S3.Y|Y3 \$I223 GND_VCO|VSS nfet_03v3 L=0.28U W=2U AS=1P
+ AD=1P PS=5U PD=5U
M$525 \$3.S5.Y|Y5|Y5_CLK_IN \$3.S4.Y|Y4 \$I224 GND_VCO|VSS nfet_03v3 L=0.28U
+ W=2U AS=1P AD=1P PS=5U PD=5U
M$526 \$3.NB1 \$3.S5.Y|Y5|Y5_CLK_IN GND_VCO|VSS GND_VCO|VSS nfet_03v3 L=0.28U
+ W=0.5U AS=0.25P AD=0.25P PS=2U PD=2U
M$527 \$3.NB2 \$3.NB1 GND_VCO|VSS GND_VCO|VSS nfet_03v3 L=0.28U W=1.5U AS=0.75P
+ AD=0.75P PS=4U PD=4U
M$528 CLK \$3.NB2 GND_VCO|VSS GND_VCO|VSS nfet_03v3 L=0.28U W=4.5U AS=2.25P
+ AD=2.25P PS=10U PD=10U
R$529 GND_VCO|VSS \$3.NC GND_VCO|VSS 16800 ppolyf_u_3k L=5.6U W=1U
R$530 GND_VCO|VSS \$3.NOFF GND_VCO|VSS 99000 ppolyf_u_3k L=33U W=1U
R$531 GND_VCO|VSS \$3.NVI GND_VCO|VSS 99000 ppolyf_u_3k L=33U W=1U
C$532 VDD_VCO GND_VCO|VSS 1.1e-11 cap_nmos_03v3 A=2500P P=200U
C$533 VDD_VCO GND_VCO|VSS 1.1e-11 cap_nmos_03v3 A=2500P P=200U
R$534 \$4.NR1 \$4.NR2 GND_VCO|VSS 18725 ppolyf_u L=107U W=2U
R$535 \$4.NR3 \$4.NR2 GND_VCO|VSS 18725 ppolyf_u L=107U W=2U
R$536 \$4.NR3 \$4.NZ GND_VCO|VSS 18725 ppolyf_u L=107U W=2U
R$537 \$4.NR1 VCTRL GND_VCO|VSS 18725 ppolyf_u L=107U W=2U
C$538 \$4.NZ GND_VCO|VSS 3.33036e-11 cap_nmos_03v3_b A=7569P P=348U
C$539 \$4.NZ GND_VCO|VSS 3.33036e-11 cap_nmos_03v3_b A=7569P P=348U
C$540 \$4.NZ GND_VCO|VSS 3.33036e-11 cap_nmos_03v3_b A=7569P P=348U
C$541 \$4.NZ GND_VCO|VSS 3.33036e-11 cap_nmos_03v3_b A=7569P P=348U
M$542 IBP IBP VDD VDD pfet_03v3 L=1U W=48U AS=24P AD=24P PS=97U PD=97U
M$543 ICP ICP VDD VDD pfet_03v3 L=1U W=12U AS=6P AD=6P PS=25U PD=25U
M$544 \$I243 \$I243 VDD VDD pfet_03v3 L=1U W=24U AS=12P AD=12P PS=49U PD=49U
M$545 \$I244 \$I243 VDD VDD pfet_03v3 L=1U W=24U AS=12P AD=12P PS=49U PD=49U
M$546 \$I245 CPB0 VDD VDD pfet_03v3 L=0.3U W=1U AS=0.5P AD=0.5P PS=3U PD=3U
M$547 \$I250 \$I245 VDD VDD pfet_03v3 L=1U W=12U AS=6P AD=6P PS=25U PD=25U
M$548 \$I246 CPB1 VDD VDD pfet_03v3 L=0.3U W=1U AS=0.5P AD=0.5P PS=3U PD=3U
M$549 \$I251 \$I246 VDD VDD pfet_03v3 L=1U W=12U AS=6P AD=6P PS=25U PD=25U
M$550 IBP \$I247 \$I245 VDD pfet_03v3 L=0.3U W=1U AS=0.5P AD=0.5P PS=3U PD=3U
M$551 IBP \$I260 \$I246 VDD pfet_03v3 L=0.3U W=1U AS=0.5P AD=0.5P PS=3U PD=3U
M$552 \$I259 ICP \$I250 VDD pfet_03v3 L=1U W=12U AS=6P AD=6P PS=25U PD=25U
M$553 \$I259 ICP \$I251 VDD pfet_03v3 L=1U W=12U AS=6P AD=6P PS=25U PD=25U
M$554 \$I256 VDD VDD VDD pfet_03v3 L=0.3U W=1U AS=0.5P AD=0.5P PS=3U PD=3U
M$555 \$I257 \$I256 VDD VDD pfet_03v3 L=1U W=12U AS=6P AD=6P PS=25U PD=25U
M$556 IBP GND_VCO|VSS \$I256 VDD pfet_03v3 L=0.3U W=1U AS=0.5P AD=0.5P PS=3U
+ PD=3U
M$557 \$I259 ICP \$I257 VDD pfet_03v3 L=1U W=12U AS=6P AD=6P PS=25U PD=25U
M$558 \$I263 IBP VDD VDD pfet_03v3 L=1U W=24U AS=12P AD=12P PS=49U PD=49U
M$559 \$I263 IBP VDD VDD pfet_03v3 L=1U W=24U AS=12P AD=12P PS=49U PD=49U
M$560 \$I264 VCTRL \$I263 \$I263 pfet_03v3 L=1U W=24U AS=12P AD=12P PS=49U
+ PD=49U
M$561 \$I244 \$I244 \$I263 \$I263 pfet_03v3 L=1U W=24U AS=12P AD=12P PS=49U
+ PD=49U
M$562 \$I244 \$I244 \$I263 \$I263 pfet_03v3 L=1U W=24U AS=12P AD=12P PS=49U
+ PD=49U
M$563 \$I264 VCTRL \$I263 \$I263 pfet_03v3 L=1U W=24U AS=12P AD=12P PS=49U
+ PD=49U
M$564 \$I265 CPB1 VDD VDD pfet_03v3 L=0.3U W=1U AS=0.5P AD=0.5P PS=3U PD=3U
M$565 \$I266 \$I265 VDD VDD pfet_03v3 L=1U W=12U AS=6P AD=6P PS=25U PD=25U
M$566 IBP \$I260 \$I265 VDD pfet_03v3 L=0.3U W=1U AS=0.5P AD=0.5P PS=3U PD=3U
M$567 \$I259 ICP \$I266 VDD pfet_03v3 L=1U W=12U AS=6P AD=6P PS=25U PD=25U
M$568 \$I259 \$I284 VCTRL VDD pfet_03v3 L=0.3U W=6U AS=3P AD=3P PS=13U PD=13U
M$569 \$I259 \$44 \$I244 VDD pfet_03v3 L=0.3U W=6U AS=3P AD=3P PS=13U PD=13U
M$570 VCTRL \$44 VCTRL VDD pfet_03v3 L=0.3U W=3U AS=1.5P AD=1.5P PS=7U PD=7U
M$571 \$I276 REF VDD VDD pfet_03v3 L=0.3U W=1.5U AS=1.5P AD=1.5P PS=5U PD=5U
M$572 \$I277 \$I276 VDD VDD pfet_03v3 L=0.3U W=1.5U AS=1.5P AD=1.5P PS=5U PD=5U
M$573 \$I278 \$I277 VDD VDD pfet_03v3 L=0.3U W=1.5U AS=1.5P AD=1.5P PS=5U PD=5U
M$574 \$I279 \$I278 VDD VDD pfet_03v3 L=0.3U W=1.5U AS=1.5P AD=1.5P PS=5U PD=5U
M$575 \$I280 \$I279 VDD VDD pfet_03v3 L=0.3U W=1.5U AS=1.5P AD=1.5P PS=5U PD=5U
M$576 \$I267 REF VDD VDD pfet_03v3 L=0.3U W=1.5U AS=1.5P AD=1.5P PS=5U PD=5U
M$577 VDD \$I280 \$I267 VDD pfet_03v3 L=0.3U W=1.5U AS=1.5P AD=1.5P PS=5U PD=5U
M$578 \$I281 \$I267 VDD VDD pfet_03v3 L=0.3U W=1.5U AS=1.5P AD=1.5P PS=5U PD=5U
M$579 \$I282 \$I281 VDD VDD pfet_03v3 L=0.3U W=1.5U AS=1.5P AD=1.5P PS=5U PD=5U
M$580 \$44 \$I282 VDD VDD pfet_03v3 L=0.3U W=1.5U AS=1.5P AD=1.5P PS=5U PD=5U
M$581 VDD \$I291 \$44 VDD pfet_03v3 L=0.3U W=1.5U AS=1.5P AD=1.5P PS=5U PD=5U
M$582 \$I291 \$I292 VDD VDD pfet_03v3 L=0.3U W=1.5U AS=1.5P AD=1.5P PS=5U PD=5U
M$583 VDD \$44 \$I291 VDD pfet_03v3 L=0.3U W=1.5U AS=1.5P AD=1.5P PS=5U PD=5U
M$584 \$I271 \$44 VDD VDD pfet_03v3 L=0.3U W=1.5U AS=1.5P AD=1.5P PS=5U PD=5U
M$585 VDD \$42 \$I271 VDD pfet_03v3 L=0.3U W=1.5U AS=1.5P AD=1.5P PS=5U PD=5U
M$586 \$I293 \$42 VDD VDD pfet_03v3 L=0.3U W=1.5U AS=1.5P AD=1.5P PS=5U PD=5U
M$587 VDD \$I292 \$I293 VDD pfet_03v3 L=0.3U W=1.5U AS=1.5P AD=1.5P PS=5U PD=5U
M$588 \$42 \$I293 VDD VDD pfet_03v3 L=0.3U W=1.5U AS=1.5P AD=1.5P PS=5U PD=5U
M$589 VDD \$I294 \$42 VDD pfet_03v3 L=0.3U W=1.5U AS=1.5P AD=1.5P PS=5U PD=5U
M$590 VDD \$I285 \$I294 VDD pfet_03v3 L=0.3U W=1.5U AS=1.5P AD=1.5P PS=5U PD=5U
M$591 VDD \$I286 \$I285 VDD pfet_03v3 L=0.3U W=1.5U AS=1.5P AD=1.5P PS=5U PD=5U
M$592 \$I286 \$I295 VDD VDD pfet_03v3 L=0.3U W=1.5U AS=1.5P AD=1.5P PS=5U PD=5U
M$593 VDD FB \$I286 VDD pfet_03v3 L=0.3U W=1.5U AS=1.5P AD=1.5P PS=5U PD=5U
M$594 VDD \$I287 \$I295 VDD pfet_03v3 L=0.3U W=1.5U AS=1.5P AD=1.5P PS=5U PD=5U
M$595 VDD \$I288 \$I287 VDD pfet_03v3 L=0.3U W=1.5U AS=1.5P AD=1.5P PS=5U PD=5U
M$596 VDD \$I289 \$I288 VDD pfet_03v3 L=0.3U W=1.5U AS=1.5P AD=1.5P PS=5U PD=5U
M$597 VDD \$I290 \$I289 VDD pfet_03v3 L=0.3U W=1.5U AS=1.5P AD=1.5P PS=5U PD=5U
M$598 VDD FB \$I290 VDD pfet_03v3 L=0.3U W=1.5U AS=1.5P AD=1.5P PS=5U PD=5U
M$599 VDD \$42 \$I283 VDD pfet_03v3 L=0.3U W=1.5U AS=0.75P AD=0.75P PS=4U PD=4U
M$600 VDD \$44 \$I284 VDD pfet_03v3 L=0.3U W=1.5U AS=0.75P AD=0.75P PS=4U PD=4U
M$601 VDD CPB0 \$I247 VDD pfet_03v3 L=0.3U W=1.5U AS=0.75P AD=0.75P PS=4U PD=4U
M$602 VDD CPB1 \$I260 VDD pfet_03v3 L=0.3U W=1.5U AS=0.75P AD=0.75P PS=4U PD=4U
M$603 \$I300 \$I271 VDD VDD pfet_03v3 L=0.3U W=1.5U AS=1.5P AD=1.5P PS=5U PD=5U
M$604 \$I301 \$I300 VDD VDD pfet_03v3 L=0.3U W=1.5U AS=1.5P AD=1.5P PS=5U PD=5U
M$605 \$I302 \$I301 VDD VDD pfet_03v3 L=0.3U W=1.5U AS=1.5P AD=1.5P PS=5U PD=5U
M$606 \$I303 \$I302 VDD VDD pfet_03v3 L=0.3U W=1.5U AS=1.5P AD=1.5P PS=5U PD=5U
M$607 \$I304 \$I303 VDD VDD pfet_03v3 L=0.3U W=1.5U AS=1.5P AD=1.5P PS=5U PD=5U
M$608 \$I305 \$I304 VDD VDD pfet_03v3 L=0.3U W=1.5U AS=1.5P AD=1.5P PS=5U PD=5U
M$609 \$I306 \$I305 VDD VDD pfet_03v3 L=0.3U W=1.5U AS=1.5P AD=1.5P PS=5U PD=5U
M$610 \$I307 \$I306 VDD VDD pfet_03v3 L=0.3U W=1.5U AS=1.5P AD=1.5P PS=5U PD=5U
M$611 \$I308 \$I307 VDD VDD pfet_03v3 L=0.3U W=1.5U AS=1.5P AD=1.5P PS=5U PD=5U
M$612 \$I309 \$I308 VDD VDD pfet_03v3 L=0.3U W=1.5U AS=1.5P AD=1.5P PS=5U PD=5U
M$613 \$I310 \$I309 VDD VDD pfet_03v3 L=0.3U W=1.5U AS=1.5P AD=1.5P PS=5U PD=5U
M$614 \$I311 \$I310 VDD VDD pfet_03v3 L=0.3U W=1.5U AS=1.5P AD=1.5P PS=5U PD=5U
M$615 \$I312 \$I311 VDD VDD pfet_03v3 L=0.3U W=1.5U AS=1.5P AD=1.5P PS=5U PD=5U
M$616 \$I313 \$I312 VDD VDD pfet_03v3 L=0.3U W=1.5U AS=1.5P AD=1.5P PS=5U PD=5U
M$617 \$I314 \$I313 VDD VDD pfet_03v3 L=0.3U W=1.5U AS=1.5P AD=1.5P PS=5U PD=5U
M$618 \$I315 \$I314 VDD VDD pfet_03v3 L=0.3U W=1.5U AS=1.5P AD=1.5P PS=5U PD=5U
M$619 \$I316 \$I315 VDD VDD pfet_03v3 L=0.3U W=1.5U AS=1.5P AD=1.5P PS=5U PD=5U
M$620 \$I317 \$I316 VDD VDD pfet_03v3 L=0.3U W=1.5U AS=1.5P AD=1.5P PS=5U PD=5U
M$621 \$I318 \$I317 VDD VDD pfet_03v3 L=0.3U W=1.5U AS=1.5P AD=1.5P PS=5U PD=5U
M$622 \$I319 \$I318 VDD VDD pfet_03v3 L=0.3U W=1.5U AS=1.5P AD=1.5P PS=5U PD=5U
M$623 \$I320 \$I319 VDD VDD pfet_03v3 L=0.3U W=1.5U AS=1.5P AD=1.5P PS=5U PD=5U
M$624 \$I321 \$I320 VDD VDD pfet_03v3 L=0.3U W=1.5U AS=1.5P AD=1.5P PS=5U PD=5U
M$625 \$I322 \$I321 VDD VDD pfet_03v3 L=0.3U W=1.5U AS=1.5P AD=1.5P PS=5U PD=5U
M$626 \$I323 \$I322 VDD VDD pfet_03v3 L=0.3U W=1.5U AS=1.5P AD=1.5P PS=5U PD=5U
M$627 \$I324 \$I323 VDD VDD pfet_03v3 L=0.3U W=1.5U AS=1.5P AD=1.5P PS=5U PD=5U
M$628 \$I292 \$I324 VDD VDD pfet_03v3 L=0.3U W=1.5U AS=1.5P AD=1.5P PS=5U PD=5U
M$629 \$I242 IBN GND_VCO|VSS GND_VCO|VSS nfet_03v3 L=1U W=16U AS=8P AD=8P
+ PS=33U PD=33U
M$630 \$I243 VCTRL \$I242 GND_VCO|VSS nfet_03v3 L=1U W=16U AS=8P AD=8P PS=33U
+ PD=33U
M$631 \$I244 \$I244 \$I242 GND_VCO|VSS nfet_03v3 L=1U W=16U AS=8P AD=8P PS=33U
+ PD=33U
M$632 IBN IBN GND_VCO|VSS GND_VCO|VSS nfet_03v3 L=1U W=16U AS=8P AD=8P PS=33U
+ PD=33U
M$633 ICN ICN GND_VCO|VSS GND_VCO|VSS nfet_03v3 L=1U W=4U AS=2P AD=2P PS=9U
+ PD=9U
M$634 \$I248 \$I247 GND_VCO|VSS GND_VCO|VSS nfet_03v3 L=0.3U W=1U AS=0.5P
+ AD=0.5P PS=3U PD=3U
M$635 \$I252 \$I248 GND_VCO|VSS GND_VCO|VSS nfet_03v3 L=1U W=4U AS=2P AD=2P
+ PS=9U PD=9U
M$636 \$I249 \$I260 GND_VCO|VSS GND_VCO|VSS nfet_03v3 L=0.3U W=1U AS=0.5P
+ AD=0.5P PS=3U PD=3U
M$637 \$I253 \$I249 GND_VCO|VSS GND_VCO|VSS nfet_03v3 L=1U W=4U AS=2P AD=2P
+ PS=9U PD=9U
M$638 IBN CPB0 \$I248 GND_VCO|VSS nfet_03v3 L=0.3U W=1U AS=0.5P AD=0.5P PS=3U
+ PD=3U
M$639 IBN CPB1 \$I249 GND_VCO|VSS nfet_03v3 L=0.3U W=1U AS=0.5P AD=0.5P PS=3U
+ PD=3U
M$640 \$I258 ICN \$I252 GND_VCO|VSS nfet_03v3 L=1U W=4U AS=2P AD=2P PS=9U PD=9U
M$641 \$I258 ICN \$I253 GND_VCO|VSS nfet_03v3 L=1U W=4U AS=2P AD=2P PS=9U PD=9U
M$642 \$I254 GND_VCO|VSS GND_VCO|VSS GND_VCO|VSS nfet_03v3 L=0.3U W=1U AS=0.5P
+ AD=0.5P PS=3U PD=3U
M$643 IBN VDD \$I254 GND_VCO|VSS nfet_03v3 L=0.3U W=1U AS=0.5P AD=0.5P PS=3U
+ PD=3U
M$644 \$I255 \$I254 GND_VCO|VSS GND_VCO|VSS nfet_03v3 L=1U W=4U AS=2P AD=2P
+ PS=9U PD=9U
M$645 \$I258 ICN \$I255 GND_VCO|VSS nfet_03v3 L=1U W=4U AS=2P AD=2P PS=9U PD=9U
M$646 \$I261 \$I260 GND_VCO|VSS GND_VCO|VSS nfet_03v3 L=0.3U W=1U AS=0.5P
+ AD=0.5P PS=3U PD=3U
M$647 \$I262 \$I261 GND_VCO|VSS GND_VCO|VSS nfet_03v3 L=1U W=4U AS=2P AD=2P
+ PS=9U PD=9U
M$648 \$I264 \$I264 GND_VCO|VSS GND_VCO|VSS nfet_03v3 L=1U W=16U AS=8P AD=8P
+ PS=33U PD=33U
M$649 \$I244 \$I264 GND_VCO|VSS GND_VCO|VSS nfet_03v3 L=1U W=16U AS=8P AD=8P
+ PS=33U PD=33U
M$650 IBN CPB1 \$I261 GND_VCO|VSS nfet_03v3 L=0.3U W=1U AS=0.5P AD=0.5P PS=3U
+ PD=3U
M$651 \$I258 ICN \$I262 GND_VCO|VSS nfet_03v3 L=1U W=4U AS=2P AD=2P PS=9U PD=9U
M$652 \$I268 REF \$I267 GND_VCO|VSS nfet_03v3 L=0.3U W=1U AS=1P AD=1P PS=4U
+ PD=4U
M$653 GND_VCO|VSS \$I280 \$I268 GND_VCO|VSS nfet_03v3 L=0.3U W=1U AS=1P AD=1P
+ PS=4U PD=4U
M$654 \$I269 \$I282 \$44 GND_VCO|VSS nfet_03v3 L=0.3U W=1U AS=1P AD=1P PS=4U
+ PD=4U
M$655 GND_VCO|VSS \$I291 \$I269 GND_VCO|VSS nfet_03v3 L=0.3U W=1U AS=1P AD=1P
+ PS=4U PD=4U
M$656 \$I270 \$I292 \$I291 GND_VCO|VSS nfet_03v3 L=0.3U W=1U AS=1P AD=1P PS=4U
+ PD=4U
M$657 GND_VCO|VSS \$44 \$I270 GND_VCO|VSS nfet_03v3 L=0.3U W=1U AS=1P AD=1P
+ PS=4U PD=4U
M$658 \$I272 \$44 \$I271 GND_VCO|VSS nfet_03v3 L=0.3U W=1U AS=1P AD=1P PS=4U
+ PD=4U
M$659 GND_VCO|VSS \$42 \$I272 GND_VCO|VSS nfet_03v3 L=0.3U W=1U AS=1P AD=1P
+ PS=4U PD=4U
M$660 \$I273 \$42 GND_VCO|VSS GND_VCO|VSS nfet_03v3 L=0.3U W=1U AS=1P AD=1P
+ PS=4U PD=4U
M$661 \$I293 \$I292 \$I273 GND_VCO|VSS nfet_03v3 L=0.3U W=1U AS=1P AD=1P PS=4U
+ PD=4U
M$662 \$I274 \$I293 GND_VCO|VSS GND_VCO|VSS nfet_03v3 L=0.3U W=1U AS=1P AD=1P
+ PS=4U PD=4U
M$663 \$42 \$I294 \$I274 GND_VCO|VSS nfet_03v3 L=0.3U W=1U AS=1P AD=1P PS=4U
+ PD=4U
M$664 \$I275 \$I295 GND_VCO|VSS GND_VCO|VSS nfet_03v3 L=0.3U W=1U AS=1P AD=1P
+ PS=4U PD=4U
M$665 \$I286 FB \$I275 GND_VCO|VSS nfet_03v3 L=0.3U W=1U AS=1P AD=1P PS=4U PD=4U
M$666 \$I276 REF GND_VCO|VSS GND_VCO|VSS nfet_03v3 L=0.3U W=0.5U AS=0.5P
+ AD=0.5P PS=3U PD=3U
M$667 \$I277 \$I276 GND_VCO|VSS GND_VCO|VSS nfet_03v3 L=0.3U W=0.5U AS=0.5P
+ AD=0.5P PS=3U PD=3U
M$668 \$I278 \$I277 GND_VCO|VSS GND_VCO|VSS nfet_03v3 L=0.3U W=0.5U AS=0.5P
+ AD=0.5P PS=3U PD=3U
M$669 \$I279 \$I278 GND_VCO|VSS GND_VCO|VSS nfet_03v3 L=0.3U W=0.5U AS=0.5P
+ AD=0.5P PS=3U PD=3U
M$670 \$I280 \$I279 GND_VCO|VSS GND_VCO|VSS nfet_03v3 L=0.3U W=0.5U AS=0.5P
+ AD=0.5P PS=3U PD=3U
M$671 \$I281 \$I267 GND_VCO|VSS GND_VCO|VSS nfet_03v3 L=0.3U W=0.5U AS=0.5P
+ AD=0.5P PS=3U PD=3U
M$672 \$I282 \$I281 GND_VCO|VSS GND_VCO|VSS nfet_03v3 L=0.3U W=0.5U AS=0.5P
+ AD=0.5P PS=3U PD=3U
M$673 GND_VCO|VSS \$I285 \$I294 GND_VCO|VSS nfet_03v3 L=0.3U W=0.5U AS=0.5P
+ AD=0.5P PS=3U PD=3U
M$674 GND_VCO|VSS \$I286 \$I285 GND_VCO|VSS nfet_03v3 L=0.3U W=0.5U AS=0.5P
+ AD=0.5P PS=3U PD=3U
M$675 GND_VCO|VSS \$I287 \$I295 GND_VCO|VSS nfet_03v3 L=0.3U W=0.5U AS=0.5P
+ AD=0.5P PS=3U PD=3U
M$676 GND_VCO|VSS \$I288 \$I287 GND_VCO|VSS nfet_03v3 L=0.3U W=0.5U AS=0.5P
+ AD=0.5P PS=3U PD=3U
M$677 GND_VCO|VSS \$I289 \$I288 GND_VCO|VSS nfet_03v3 L=0.3U W=0.5U AS=0.5P
+ AD=0.5P PS=3U PD=3U
M$678 GND_VCO|VSS \$I290 \$I289 GND_VCO|VSS nfet_03v3 L=0.3U W=0.5U AS=0.5P
+ AD=0.5P PS=3U PD=3U
M$679 GND_VCO|VSS FB \$I290 GND_VCO|VSS nfet_03v3 L=0.3U W=0.5U AS=0.5P AD=0.5P
+ PS=3U PD=3U
M$680 \$I283 \$42 GND_VCO|VSS GND_VCO|VSS nfet_03v3 L=0.3U W=0.5U AS=0.25P
+ AD=0.25P PS=2U PD=2U
M$681 VCTRL \$42 \$I258 GND_VCO|VSS nfet_03v3 L=0.3U W=6U AS=3P AD=3P PS=13U
+ PD=13U
M$682 \$I244 \$I283 \$I258 GND_VCO|VSS nfet_03v3 L=0.3U W=6U AS=3P AD=3P PS=13U
+ PD=13U
M$683 VCTRL \$I283 VCTRL GND_VCO|VSS nfet_03v3 L=0.3U W=3U AS=1.5P AD=1.5P
+ PS=7U PD=7U
M$684 \$I284 \$44 GND_VCO|VSS GND_VCO|VSS nfet_03v3 L=0.3U W=0.5U AS=0.25P
+ AD=0.25P PS=2U PD=2U
M$685 \$I247 CPB0 GND_VCO|VSS GND_VCO|VSS nfet_03v3 L=0.3U W=0.5U AS=0.25P
+ AD=0.25P PS=2U PD=2U
M$686 \$I260 CPB1 GND_VCO|VSS GND_VCO|VSS nfet_03v3 L=0.3U W=0.5U AS=0.25P
+ AD=0.25P PS=2U PD=2U
M$687 \$I300 \$I271 GND_VCO|VSS GND_VCO|VSS nfet_03v3 L=0.3U W=0.5U AS=0.5P
+ AD=0.5P PS=3U PD=3U
M$688 \$I301 \$I300 GND_VCO|VSS GND_VCO|VSS nfet_03v3 L=0.3U W=0.5U AS=0.5P
+ AD=0.5P PS=3U PD=3U
M$689 \$I302 \$I301 GND_VCO|VSS GND_VCO|VSS nfet_03v3 L=0.3U W=0.5U AS=0.5P
+ AD=0.5P PS=3U PD=3U
M$690 \$I303 \$I302 GND_VCO|VSS GND_VCO|VSS nfet_03v3 L=0.3U W=0.5U AS=0.5P
+ AD=0.5P PS=3U PD=3U
M$691 \$I304 \$I303 GND_VCO|VSS GND_VCO|VSS nfet_03v3 L=0.3U W=0.5U AS=0.5P
+ AD=0.5P PS=3U PD=3U
M$692 \$I305 \$I304 GND_VCO|VSS GND_VCO|VSS nfet_03v3 L=0.3U W=0.5U AS=0.5P
+ AD=0.5P PS=3U PD=3U
M$693 \$I306 \$I305 GND_VCO|VSS GND_VCO|VSS nfet_03v3 L=0.3U W=0.5U AS=0.5P
+ AD=0.5P PS=3U PD=3U
M$694 \$I307 \$I306 GND_VCO|VSS GND_VCO|VSS nfet_03v3 L=0.3U W=0.5U AS=0.5P
+ AD=0.5P PS=3U PD=3U
M$695 \$I308 \$I307 GND_VCO|VSS GND_VCO|VSS nfet_03v3 L=0.3U W=0.5U AS=0.5P
+ AD=0.5P PS=3U PD=3U
M$696 \$I309 \$I308 GND_VCO|VSS GND_VCO|VSS nfet_03v3 L=0.3U W=0.5U AS=0.5P
+ AD=0.5P PS=3U PD=3U
M$697 \$I310 \$I309 GND_VCO|VSS GND_VCO|VSS nfet_03v3 L=0.3U W=0.5U AS=0.5P
+ AD=0.5P PS=3U PD=3U
M$698 \$I311 \$I310 GND_VCO|VSS GND_VCO|VSS nfet_03v3 L=0.3U W=0.5U AS=0.5P
+ AD=0.5P PS=3U PD=3U
M$699 \$I312 \$I311 GND_VCO|VSS GND_VCO|VSS nfet_03v3 L=0.3U W=0.5U AS=0.5P
+ AD=0.5P PS=3U PD=3U
M$700 \$I313 \$I312 GND_VCO|VSS GND_VCO|VSS nfet_03v3 L=0.3U W=0.5U AS=0.5P
+ AD=0.5P PS=3U PD=3U
M$701 \$I314 \$I313 GND_VCO|VSS GND_VCO|VSS nfet_03v3 L=0.3U W=0.5U AS=0.5P
+ AD=0.5P PS=3U PD=3U
M$702 \$I315 \$I314 GND_VCO|VSS GND_VCO|VSS nfet_03v3 L=0.3U W=0.5U AS=0.5P
+ AD=0.5P PS=3U PD=3U
M$703 \$I316 \$I315 GND_VCO|VSS GND_VCO|VSS nfet_03v3 L=0.3U W=0.5U AS=0.5P
+ AD=0.5P PS=3U PD=3U
M$704 \$I317 \$I316 GND_VCO|VSS GND_VCO|VSS nfet_03v3 L=0.3U W=0.5U AS=0.5P
+ AD=0.5P PS=3U PD=3U
M$705 \$I318 \$I317 GND_VCO|VSS GND_VCO|VSS nfet_03v3 L=0.3U W=0.5U AS=0.5P
+ AD=0.5P PS=3U PD=3U
M$706 \$I319 \$I318 GND_VCO|VSS GND_VCO|VSS nfet_03v3 L=0.3U W=0.5U AS=0.5P
+ AD=0.5P PS=3U PD=3U
M$707 \$I320 \$I319 GND_VCO|VSS GND_VCO|VSS nfet_03v3 L=0.3U W=0.5U AS=0.5P
+ AD=0.5P PS=3U PD=3U
M$708 \$I321 \$I320 GND_VCO|VSS GND_VCO|VSS nfet_03v3 L=0.3U W=0.5U AS=0.5P
+ AD=0.5P PS=3U PD=3U
M$709 \$I322 \$I321 GND_VCO|VSS GND_VCO|VSS nfet_03v3 L=0.3U W=0.5U AS=0.5P
+ AD=0.5P PS=3U PD=3U
M$710 \$I323 \$I322 GND_VCO|VSS GND_VCO|VSS nfet_03v3 L=0.3U W=0.5U AS=0.5P
+ AD=0.5P PS=3U PD=3U
M$711 \$I324 \$I323 GND_VCO|VSS GND_VCO|VSS nfet_03v3 L=0.3U W=0.5U AS=0.5P
+ AD=0.5P PS=3U PD=3U
M$712 \$I292 \$I324 GND_VCO|VSS GND_VCO|VSS nfet_03v3 L=0.3U W=0.5U AS=0.5P
+ AD=0.5P PS=3U PD=3U
M$713 \$1.XERR_N1 \$44 VDD VDD pfet_03v3 L=0.28U W=2.5U AS=2.5P AD=2.5P PS=7U
+ PD=7U
M$714 \$1.XERR_N1 \$42 VDD VDD pfet_03v3 L=0.28U W=2.5U AS=2.5P AD=2.5P PS=7U
+ PD=7U
M$715 \$1.XERR_N2 \$44 VDD VDD pfet_03v3 L=0.28U W=2.5U AS=2.5P AD=2.5P PS=7U
+ PD=7U
M$716 \$1.XERR_N2 \$1.XERR_N1 VDD VDD pfet_03v3 L=0.28U W=2.5U AS=2.5P AD=2.5P
+ PS=7U PD=7U
M$717 \$1.XERR_N3 \$42 VDD VDD pfet_03v3 L=0.28U W=2.5U AS=2.5P AD=2.5P PS=7U
+ PD=7U
M$718 \$1.XERR_N3 \$1.XERR_N1 VDD VDD pfet_03v3 L=0.28U W=2.5U AS=2.5P AD=2.5P
+ PS=7U PD=7U
M$719 \$1.ERR \$1.XERR_N2 VDD VDD pfet_03v3 L=0.28U W=2.5U AS=2.5P AD=2.5P
+ PS=7U PD=7U
M$720 \$1.ERR \$1.XERR_N3 VDD VDD pfet_03v3 L=0.28U W=2.5U AS=2.5P AD=2.5P
+ PS=7U PD=7U
M$721 \$1.XDLY_T0B LDT0 VDD VDD pfet_03v3 L=0.28U W=2.5U AS=2.5P AD=2.5P PS=7U
+ PD=7U
M$722 \$1.XDLY_T1B LDT1 VDD VDD pfet_03v3 L=0.28U W=2.5U AS=2.5P AD=2.5P PS=7U
+ PD=7U
M$723 \$1.XDLY_T2B LDT2 VDD VDD pfet_03v3 L=0.28U W=2.5U AS=2.5P AD=2.5P PS=7U
+ PD=7U
M$724 \$1.XDLY_T3B LDT3 VDD VDD pfet_03v3 L=0.28U W=2.5U AS=2.5P AD=2.5P PS=7U
+ PD=7U
M$725 \$1.XDLY_D1 \$1.ERR VDD VDD pfet_03v3 L=0.28U W=2.5U AS=2.5P AD=2.5P
+ PS=7U PD=7U
M$726 \$1.XDLY_D2 \$1.XDLY_D1 VDD VDD pfet_03v3 L=0.28U W=2.5U AS=2.5P AD=2.5P
+ PS=7U PD=7U
M$727 \$1.XDLY_D3 \$1.XDLY_D2 VDD VDD pfet_03v3 L=0.28U W=2.5U AS=2.5P AD=2.5P
+ PS=7U PD=7U
M$728 \$1.ERRD \$1.XDLY_D3 VDD VDD pfet_03v3 L=0.28U W=2.5U AS=2.5P AD=2.5P
+ PS=7U PD=7U
M$729 \$1.WIDEB \$1.ERR VDD VDD pfet_03v3 L=0.28U W=2.5U AS=2.5P AD=2.5P PS=7U
+ PD=7U
M$730 \$1.WIDEB \$1.ERRD VDD VDD pfet_03v3 L=0.28U W=2.5U AS=2.5P AD=2.5P PS=7U
+ PD=7U
M$731 \$1.WIDE \$1.WIDEB VDD VDD pfet_03v3 L=0.28U W=2.5U AS=2.5P AD=2.5P PS=7U
+ PD=7U
M$732 \$1.XSCH_P1 \$1.VWIN VDD VDD pfet_03v3 L=0.28U W=2.5U AS=2.5P AD=2.5P
+ PS=7U PD=7U
M$733 \$1.LOCKB \$1.VWIN \$1.XSCH_P1 VDD pfet_03v3 L=0.28U W=2.5U AS=2.5P
+ AD=2.5P PS=7U PD=7U
M$734 LOCK \$1.LOCKB VDD VDD pfet_03v3 L=0.28U W=2.5U AS=2.5P AD=2.5P PS=7U
+ PD=7U
M$735 \$1.XDLY_S10 \$1.XDLY_T0B \$1.XDLY_D1 VDD pfet_03v3 L=0.28U W=0.22U
+ AS=0.43P AD=0.43P PS=3U PD=3U
M$736 \$1.XDLY_S11 \$1.XDLY_T1B \$1.XDLY_D1 VDD pfet_03v3 L=0.28U W=0.44U
+ AS=0.44P AD=0.44P PS=2.88U PD=2.88U
M$737 \$1.XDLY_S12 \$1.XDLY_T2B \$1.XDLY_D1 VDD pfet_03v3 L=0.28U W=0.88U
+ AS=0.88P AD=0.88P PS=3.76U PD=3.76U
M$738 \$1.XDLY_S13 \$1.XDLY_T3B \$1.XDLY_D1 VDD pfet_03v3 L=0.28U W=1.76U
+ AS=1.76P AD=1.76P PS=5.52U PD=5.52U
M$739 \$1.XDLY_S20 \$1.XDLY_T0B \$1.XDLY_D2 VDD pfet_03v3 L=0.28U W=0.22U
+ AS=0.43P AD=0.43P PS=3U PD=3U
M$740 \$1.XDLY_S21 \$1.XDLY_T1B \$1.XDLY_D2 VDD pfet_03v3 L=0.28U W=0.44U
+ AS=0.44P AD=0.44P PS=2.88U PD=2.88U
M$741 \$1.XDLY_S22 \$1.XDLY_T2B \$1.XDLY_D2 VDD pfet_03v3 L=0.28U W=0.88U
+ AS=0.88P AD=0.88P PS=3.76U PD=3.76U
M$742 \$1.XDLY_S23 \$1.XDLY_T3B \$1.XDLY_D2 VDD pfet_03v3 L=0.28U W=1.76U
+ AS=1.76P AD=1.76P PS=5.52U PD=5.52U
M$743 \$1.XDLY_S30 \$1.XDLY_T0B \$1.XDLY_D3 VDD pfet_03v3 L=0.28U W=0.22U
+ AS=0.43P AD=0.43P PS=3U PD=3U
M$744 \$1.XDLY_S31 \$1.XDLY_T1B \$1.XDLY_D3 VDD pfet_03v3 L=0.28U W=0.44U
+ AS=0.44P AD=0.44P PS=2.88U PD=2.88U
M$745 \$1.XDLY_S32 \$1.XDLY_T2B \$1.XDLY_D3 VDD pfet_03v3 L=0.28U W=0.88U
+ AS=0.88P AD=0.88P PS=3.76U PD=3.76U
M$746 \$1.XDLY_S33 \$1.XDLY_T3B \$1.XDLY_D3 VDD pfet_03v3 L=0.28U W=1.76U
+ AS=1.76P AD=1.76P PS=5.52U PD=5.52U
M$747 \$1.XDLY_S40 \$1.XDLY_T0B \$1.ERRD VDD pfet_03v3 L=0.28U W=0.22U AS=0.43P
+ AD=0.43P PS=3U PD=3U
M$748 \$1.XDLY_S41 \$1.XDLY_T1B \$1.ERRD VDD pfet_03v3 L=0.28U W=0.44U AS=0.44P
+ AD=0.44P PS=2.88U PD=2.88U
M$749 \$1.XDLY_S42 \$1.XDLY_T2B \$1.ERRD VDD pfet_03v3 L=0.28U W=0.88U AS=0.88P
+ AD=0.88P PS=3.76U PD=3.76U
M$750 \$1.XDLY_S43 \$1.XDLY_T3B \$1.ERRD VDD pfet_03v3 L=0.28U W=1.76U AS=1.76P
+ AD=1.76P PS=5.52U PD=5.52U
M$751 \$1.VWIN GND_VCO|VSS VDD VDD pfet_03v3 L=20U W=0.22U AS=0.43P AD=0.43P
+ PS=3U PD=3U
M$752 GND_VCO|VSS \$1.LOCKB \$1.XSCH_P1 VDD pfet_03v3 L=0.28U W=1.2U AS=1.2P
+ AD=1.2P PS=4.4U PD=4.4U
M$753 \$1.XERR_N1 \$44 \$1.XERR_G1_NMID GND_VCO|VSS nfet_03v3 L=0.28U W=2U
+ AS=2P AD=2P PS=6U PD=6U
M$754 \$1.XERR_G1_NMID \$42 GND_VCO|VSS GND_VCO|VSS nfet_03v3 L=0.28U W=2U
+ AS=2P AD=2P PS=6U PD=6U
M$755 \$1.XERR_N2 \$44 \$1.XERR_G2_NMID GND_VCO|VSS nfet_03v3 L=0.28U W=2U
+ AS=2P AD=2P PS=6U PD=6U
M$756 \$1.XERR_G2_NMID \$1.XERR_N1 GND_VCO|VSS GND_VCO|VSS nfet_03v3 L=0.28U
+ W=2U AS=2P AD=2P PS=6U PD=6U
M$757 \$1.XERR_N3 \$42 \$1.XERR_G3_NMID GND_VCO|VSS nfet_03v3 L=0.28U W=2U
+ AS=2P AD=2P PS=6U PD=6U
M$758 \$1.XERR_G3_NMID \$1.XERR_N1 GND_VCO|VSS GND_VCO|VSS nfet_03v3 L=0.28U
+ W=2U AS=2P AD=2P PS=6U PD=6U
M$759 \$1.ERR \$1.XERR_N2 \$1.XERR_G4_NMID GND_VCO|VSS nfet_03v3 L=0.28U W=2U
+ AS=2P AD=2P PS=6U PD=6U
M$760 \$1.XERR_G4_NMID \$1.XERR_N3 GND_VCO|VSS GND_VCO|VSS nfet_03v3 L=0.28U
+ W=2U AS=2P AD=2P PS=6U PD=6U
M$761 \$1.WIDEB \$1.ERR \$1.XNW_NMID GND_VCO|VSS nfet_03v3 L=0.28U W=2U AS=2P
+ AD=2P PS=6U PD=6U
M$762 \$1.XNW_NMID \$1.ERRD GND_VCO|VSS GND_VCO|VSS nfet_03v3 L=0.28U W=2U
+ AS=2P AD=2P PS=6U PD=6U
M$763 \$1.VWIN \$1.WIDE GND_VCO|VSS GND_VCO|VSS nfet_03v3 L=0.5U W=2U AS=2P
+ AD=2P PS=6U PD=6U
M$764 \$1.XDLY_T0B LDT0 GND_VCO|VSS GND_VCO|VSS nfet_03v3 L=0.28U W=1U AS=1P
+ AD=1P PS=4U PD=4U
M$765 \$1.XDLY_T1B LDT1 GND_VCO|VSS GND_VCO|VSS nfet_03v3 L=0.28U W=1U AS=1P
+ AD=1P PS=4U PD=4U
M$766 \$1.XDLY_T2B LDT2 GND_VCO|VSS GND_VCO|VSS nfet_03v3 L=0.28U W=1U AS=1P
+ AD=1P PS=4U PD=4U
M$767 \$1.XDLY_T3B LDT3 GND_VCO|VSS GND_VCO|VSS nfet_03v3 L=0.28U W=1U AS=1P
+ AD=1P PS=4U PD=4U
M$768 \$1.XDLY_D1 \$1.ERR GND_VCO|VSS GND_VCO|VSS nfet_03v3 L=0.28U W=1U AS=1P
+ AD=1P PS=4U PD=4U
M$769 \$1.XDLY_D1 LDT3 \$1.XDLY_S13 GND_VCO|VSS nfet_03v3 L=0.28U W=1.76U
+ AS=1.76P AD=1.76P PS=5.52U PD=5.52U
M$770 \$1.XDLY_S13 \$1.XDLY_T3B GND_VCO|VSS GND_VCO|VSS nfet_03v3 L=0.5U
+ W=1.76U AS=1.76P AD=1.76P PS=5.52U PD=5.52U
M$771 \$1.XDLY_D2 \$1.XDLY_D1 GND_VCO|VSS GND_VCO|VSS nfet_03v3 L=0.28U W=1U
+ AS=1P AD=1P PS=4U PD=4U
M$772 \$1.XDLY_D2 LDT3 \$1.XDLY_S23 GND_VCO|VSS nfet_03v3 L=0.28U W=1.76U
+ AS=1.76P AD=1.76P PS=5.52U PD=5.52U
M$773 \$1.XDLY_S23 \$1.XDLY_T3B GND_VCO|VSS GND_VCO|VSS nfet_03v3 L=0.5U
+ W=1.76U AS=1.76P AD=1.76P PS=5.52U PD=5.52U
M$774 \$1.XDLY_D3 \$1.XDLY_D2 GND_VCO|VSS GND_VCO|VSS nfet_03v3 L=0.28U W=1U
+ AS=1P AD=1P PS=4U PD=4U
M$775 \$1.XDLY_D3 LDT3 \$1.XDLY_S33 GND_VCO|VSS nfet_03v3 L=0.28U W=1.76U
+ AS=1.76P AD=1.76P PS=5.52U PD=5.52U
M$776 \$1.XDLY_S33 \$1.XDLY_T3B GND_VCO|VSS GND_VCO|VSS nfet_03v3 L=0.5U
+ W=1.76U AS=1.76P AD=1.76P PS=5.52U PD=5.52U
M$777 \$1.ERRD \$1.XDLY_D3 GND_VCO|VSS GND_VCO|VSS nfet_03v3 L=0.28U W=1U AS=1P
+ AD=1P PS=4U PD=4U
M$778 \$1.ERRD LDT3 \$1.XDLY_S43 GND_VCO|VSS nfet_03v3 L=0.28U W=1.76U AS=1.76P
+ AD=1.76P PS=5.52U PD=5.52U
M$779 \$1.XDLY_S43 \$1.XDLY_T3B GND_VCO|VSS GND_VCO|VSS nfet_03v3 L=0.5U
+ W=1.76U AS=1.76P AD=1.76P PS=5.52U PD=5.52U
M$780 \$1.WIDE \$1.WIDEB GND_VCO|VSS GND_VCO|VSS nfet_03v3 L=0.28U W=1U AS=1P
+ AD=1P PS=4U PD=4U
M$781 \$1.XSCH_N1 \$1.VWIN GND_VCO|VSS GND_VCO|VSS nfet_03v3 L=0.28U W=1U AS=1P
+ AD=1P PS=4U PD=4U
M$782 \$1.LOCKB \$1.VWIN \$1.XSCH_N1 GND_VCO|VSS nfet_03v3 L=0.28U W=1U AS=1P
+ AD=1P PS=4U PD=4U
M$783 LOCK \$1.LOCKB GND_VCO|VSS GND_VCO|VSS nfet_03v3 L=0.28U W=1U AS=1P AD=1P
+ PS=4U PD=4U
M$784 GND_VCO|VSS \$1.XDLY_D1 GND_VCO|VSS GND_VCO|VSS nfet_03v3 L=2U W=6.2U
+ AS=6.2P AD=6.2P PS=14.4U PD=14.4U
M$785 \$1.XDLY_D1 LDT0 \$1.XDLY_S10 GND_VCO|VSS nfet_03v3 L=0.28U W=0.22U
+ AS=0.43P AD=0.43P PS=3U PD=3U
M$786 \$1.XDLY_S10 \$1.XDLY_T0B GND_VCO|VSS GND_VCO|VSS nfet_03v3 L=0.5U
+ W=0.22U AS=0.43P AD=0.43P PS=3U PD=3U
M$787 \$1.XDLY_D1 LDT1 \$1.XDLY_S11 GND_VCO|VSS nfet_03v3 L=0.28U W=0.44U
+ AS=0.44P AD=0.44P PS=2.88U PD=2.88U
M$788 \$1.XDLY_S11 \$1.XDLY_T1B GND_VCO|VSS GND_VCO|VSS nfet_03v3 L=0.5U
+ W=0.44U AS=0.44P AD=0.44P PS=2.88U PD=2.88U
M$789 \$1.XDLY_D1 LDT2 \$1.XDLY_S12 GND_VCO|VSS nfet_03v3 L=0.28U W=0.88U
+ AS=0.88P AD=0.88P PS=3.76U PD=3.76U
M$790 \$1.XDLY_S12 \$1.XDLY_T2B GND_VCO|VSS GND_VCO|VSS nfet_03v3 L=0.5U
+ W=0.88U AS=0.88P AD=0.88P PS=3.76U PD=3.76U
M$791 GND_VCO|VSS \$1.XDLY_S13 GND_VCO|VSS GND_VCO|VSS nfet_03v3 L=1U W=4U
+ AS=4P AD=4P PS=10U PD=10U
M$792 GND_VCO|VSS \$1.XDLY_D2 GND_VCO|VSS GND_VCO|VSS nfet_03v3 L=2U W=6.2U
+ AS=6.2P AD=6.2P PS=14.4U PD=14.4U
M$793 \$1.XDLY_D2 LDT0 \$1.XDLY_S20 GND_VCO|VSS nfet_03v3 L=0.28U W=0.22U
+ AS=0.43P AD=0.43P PS=3U PD=3U
M$794 \$1.XDLY_S20 \$1.XDLY_T0B GND_VCO|VSS GND_VCO|VSS nfet_03v3 L=0.5U
+ W=0.22U AS=0.43P AD=0.43P PS=3U PD=3U
M$795 \$1.XDLY_D2 LDT1 \$1.XDLY_S21 GND_VCO|VSS nfet_03v3 L=0.28U W=0.44U
+ AS=0.44P AD=0.44P PS=2.88U PD=2.88U
M$796 \$1.XDLY_S21 \$1.XDLY_T1B GND_VCO|VSS GND_VCO|VSS nfet_03v3 L=0.5U
+ W=0.44U AS=0.44P AD=0.44P PS=2.88U PD=2.88U
M$797 \$1.XDLY_D2 LDT2 \$1.XDLY_S22 GND_VCO|VSS nfet_03v3 L=0.28U W=0.88U
+ AS=0.88P AD=0.88P PS=3.76U PD=3.76U
M$798 \$1.XDLY_S22 \$1.XDLY_T2B GND_VCO|VSS GND_VCO|VSS nfet_03v3 L=0.5U
+ W=0.88U AS=0.88P AD=0.88P PS=3.76U PD=3.76U
M$799 GND_VCO|VSS \$1.XDLY_S23 GND_VCO|VSS GND_VCO|VSS nfet_03v3 L=1U W=4U
+ AS=4P AD=4P PS=10U PD=10U
M$800 GND_VCO|VSS \$1.XDLY_D3 GND_VCO|VSS GND_VCO|VSS nfet_03v3 L=2U W=6.2U
+ AS=6.2P AD=6.2P PS=14.4U PD=14.4U
M$801 \$1.XDLY_D3 LDT0 \$1.XDLY_S30 GND_VCO|VSS nfet_03v3 L=0.28U W=0.22U
+ AS=0.43P AD=0.43P PS=3U PD=3U
M$802 \$1.XDLY_S30 \$1.XDLY_T0B GND_VCO|VSS GND_VCO|VSS nfet_03v3 L=0.5U
+ W=0.22U AS=0.43P AD=0.43P PS=3U PD=3U
M$803 \$1.XDLY_D3 LDT1 \$1.XDLY_S31 GND_VCO|VSS nfet_03v3 L=0.28U W=0.44U
+ AS=0.44P AD=0.44P PS=2.88U PD=2.88U
M$804 \$1.XDLY_S31 \$1.XDLY_T1B GND_VCO|VSS GND_VCO|VSS nfet_03v3 L=0.5U
+ W=0.44U AS=0.44P AD=0.44P PS=2.88U PD=2.88U
M$805 \$1.XDLY_D3 LDT2 \$1.XDLY_S32 GND_VCO|VSS nfet_03v3 L=0.28U W=0.88U
+ AS=0.88P AD=0.88P PS=3.76U PD=3.76U
M$806 \$1.XDLY_S32 \$1.XDLY_T2B GND_VCO|VSS GND_VCO|VSS nfet_03v3 L=0.5U
+ W=0.88U AS=0.88P AD=0.88P PS=3.76U PD=3.76U
M$807 GND_VCO|VSS \$1.XDLY_S33 GND_VCO|VSS GND_VCO|VSS nfet_03v3 L=1U W=4U
+ AS=4P AD=4P PS=10U PD=10U
M$808 GND_VCO|VSS \$1.ERRD GND_VCO|VSS GND_VCO|VSS nfet_03v3 L=2U W=6.2U
+ AS=6.2P AD=6.2P PS=14.4U PD=14.4U
M$809 \$1.ERRD LDT0 \$1.XDLY_S40 GND_VCO|VSS nfet_03v3 L=0.28U W=0.22U AS=0.43P
+ AD=0.43P PS=3U PD=3U
M$810 \$1.XDLY_S40 \$1.XDLY_T0B GND_VCO|VSS GND_VCO|VSS nfet_03v3 L=0.5U
+ W=0.22U AS=0.43P AD=0.43P PS=3U PD=3U
M$811 \$1.ERRD LDT1 \$1.XDLY_S41 GND_VCO|VSS nfet_03v3 L=0.28U W=0.44U AS=0.44P
+ AD=0.44P PS=2.88U PD=2.88U
M$812 \$1.XDLY_S41 \$1.XDLY_T1B GND_VCO|VSS GND_VCO|VSS nfet_03v3 L=0.5U
+ W=0.44U AS=0.44P AD=0.44P PS=2.88U PD=2.88U
M$813 \$1.ERRD LDT2 \$1.XDLY_S42 GND_VCO|VSS nfet_03v3 L=0.28U W=0.88U AS=0.88P
+ AD=0.88P PS=3.76U PD=3.76U
M$814 \$1.XDLY_S42 \$1.XDLY_T2B GND_VCO|VSS GND_VCO|VSS nfet_03v3 L=0.5U
+ W=0.88U AS=0.88P AD=0.88P PS=3.76U PD=3.76U
M$815 GND_VCO|VSS \$1.XDLY_S43 GND_VCO|VSS GND_VCO|VSS nfet_03v3 L=1U W=4U
+ AS=4P AD=4P PS=10U PD=10U
M$816 VDD \$1.LOCKB \$1.XSCH_N1 GND_VCO|VSS nfet_03v3 L=0.28U W=0.5U AS=0.5P
+ AD=0.5P PS=3U PD=3U
M$817 GND_VCO|VSS \$1.XDLY_S11 GND_VCO|VSS GND_VCO|VSS nfet_03v3 L=1U W=1U
+ AS=1P AD=1P PS=4U PD=4U
M$818 GND_VCO|VSS \$1.XDLY_S12 GND_VCO|VSS GND_VCO|VSS nfet_03v3 L=1U W=2U
+ AS=2P AD=2P PS=6U PD=6U
M$819 GND_VCO|VSS \$1.XDLY_S21 GND_VCO|VSS GND_VCO|VSS nfet_03v3 L=1U W=1U
+ AS=1P AD=1P PS=4U PD=4U
M$820 GND_VCO|VSS \$1.XDLY_S22 GND_VCO|VSS GND_VCO|VSS nfet_03v3 L=1U W=2U
+ AS=2P AD=2P PS=6U PD=6U
M$821 GND_VCO|VSS \$1.XDLY_S31 GND_VCO|VSS GND_VCO|VSS nfet_03v3 L=1U W=1U
+ AS=1P AD=1P PS=4U PD=4U
M$822 GND_VCO|VSS \$1.XDLY_S32 GND_VCO|VSS GND_VCO|VSS nfet_03v3 L=1U W=2U
+ AS=2P AD=2P PS=6U PD=6U
M$823 GND_VCO|VSS \$1.XDLY_S41 GND_VCO|VSS GND_VCO|VSS nfet_03v3 L=1U W=1U
+ AS=1P AD=1P PS=4U PD=4U
M$824 GND_VCO|VSS \$1.XDLY_S42 GND_VCO|VSS GND_VCO|VSS nfet_03v3 L=1U W=2U
+ AS=2P AD=2P PS=6U PD=6U
M$825 GND_VCO|VSS \$1.XDLY_S10 GND_VCO|VSS GND_VCO|VSS nfet_03v3 L=1U W=0.5U
+ AS=0.5P AD=0.5P PS=3U PD=3U
M$826 GND_VCO|VSS \$1.XDLY_S20 GND_VCO|VSS GND_VCO|VSS nfet_03v3 L=1U W=0.5U
+ AS=0.5P AD=0.5P PS=3U PD=3U
M$827 GND_VCO|VSS \$1.XDLY_S30 GND_VCO|VSS GND_VCO|VSS nfet_03v3 L=1U W=0.5U
+ AS=0.5P AD=0.5P PS=3U PD=3U
M$828 GND_VCO|VSS \$1.XDLY_S40 GND_VCO|VSS GND_VCO|VSS nfet_03v3 L=1U W=0.5U
+ AS=0.5P AD=0.5P PS=3U PD=3U
M$829 GND_VCO|VSS \$1.VWIN GND_VCO|VSS GND_VCO|VSS nfet_03v3 L=6U W=30U AS=30P
+ AD=30P PS=62U PD=62U
.ENDS pll_top
