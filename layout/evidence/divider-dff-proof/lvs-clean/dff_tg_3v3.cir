* Extracted by KLayout with GF180MCU LVS runset on : 09/09/2026 01:10

.SUBCKT dff_tg_3v3 VSS D Q QB VDD CK
M$1 VDD \$8 Q VDD pfet_03v3 L=0.28U W=2.5U AS=1.25P AD=1.25P PS=6U PD=6U
M$2 \$7 \$3 \$5 VDD pfet_03v3 L=0.28U W=2.5U AS=1.25P AD=1.25P PS=6U PD=6U
M$3 VDD \$5 \$6 VDD pfet_03v3 L=0.28U W=2.5U AS=1.25P AD=1.25P PS=6U PD=6U
M$4 VDD CK \$3 VDD pfet_03v3 L=0.28U W=2.5U AS=1.25P AD=1.25P PS=6U PD=6U
M$5 VDD \$3 \$4 VDD pfet_03v3 L=0.28U W=2.5U AS=1.25P AD=1.25P PS=6U PD=6U
M$6 D \$4 \$5 VDD pfet_03v3 L=0.28U W=2.5U AS=1.25P AD=1.25P PS=6U PD=6U
M$7 \$6 \$3 \$8 VDD pfet_03v3 L=0.28U W=2.5U AS=1.25P AD=1.25P PS=6U PD=6U
M$8 VDD \$6 \$7 VDD pfet_03v3 L=0.28U W=2.5U AS=1.25P AD=1.25P PS=6U PD=6U
M$9 VDD Q QB VDD pfet_03v3 L=0.28U W=2.5U AS=1.25P AD=1.25P PS=6U PD=6U
M$10 QB \$4 \$8 VDD pfet_03v3 L=0.28U W=2.5U AS=1.25P AD=1.25P PS=6U PD=6U
M$11 \$8 \$3 QB VSS nfet_03v3 L=0.28U W=1U AS=0.5P AD=0.5P PS=3U PD=3U
M$12 QB Q VSS VSS nfet_03v3 L=0.28U W=1U AS=0.5P AD=0.5P PS=3U PD=3U
M$13 Q \$8 VSS VSS nfet_03v3 L=0.28U W=1U AS=0.5P AD=0.5P PS=3U PD=3U
M$14 \$6 \$5 VSS VSS nfet_03v3 L=0.28U W=1U AS=0.5P AD=0.5P PS=3U PD=3U
M$15 \$3 CK VSS VSS nfet_03v3 L=0.28U W=1U AS=0.5P AD=0.5P PS=3U PD=3U
M$16 \$8 \$4 \$6 VSS nfet_03v3 L=0.28U W=1U AS=0.5P AD=0.5P PS=3U PD=3U
M$17 \$4 \$3 VSS VSS nfet_03v3 L=0.28U W=1U AS=0.5P AD=0.5P PS=3U PD=3U
M$18 \$5 \$3 D VSS nfet_03v3 L=0.28U W=1U AS=0.5P AD=0.5P PS=3U PD=3U
M$19 \$7 \$6 VSS VSS nfet_03v3 L=0.28U W=1U AS=0.5P AD=0.5P PS=3U PD=3U
M$20 \$5 \$4 \$7 VSS nfet_03v3 L=0.28U W=1U AS=0.5P AD=0.5P PS=3U PD=3U
.ENDS dff_tg_3v3
