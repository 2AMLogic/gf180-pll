* Extracted by KLayout with GF180MCU LVS runset on : 22/09/2026 22:04

.SUBCKT divider_chain MO0 P1 P2 VSS MA MB SEL0 SEL1 MO3 SEL2 VCO MO1 MO2
+ DIVOUTB DIVOUT CK1 NMI0 XM0_NMID CK2 NMI1 XM1_NMID CK3 NMI2 XM2_NMID XMA_NM2
+ MI0 P0 T0 MI1 T1 MI2 T2 XMA_NM1 VDD_DIV XMNO_PMID XNR0_PMID XNR1_PMID
+ XNR2_PMID P3 CK4 P5 CK6 MO4 SEL3 MO5 SEL4 XFRT_CKB XFRT_CKBB XFRT_NM XFRT_NMA
+ XFRT_NMB XFRT_NS FB FBB NMI3 XM3_NMID NMI4 XM4_NMID XM5_NMID XMB_NM2
+ XNR3_PMID T3 P4 CK5 XNR4_PMID T4 T5 XMB_NM1 MI3 MI4 SEL5
M$1 XMNO_PMID MB DIVOUTB VDD_DIV pfet_03v3 L=0.28U W=5U AS=2.5P AD=2.5P PS=11U
+ PD=11U
M$2 VDD_DIV DIVOUTB DIVOUT VDD_DIV pfet_03v3 L=0.28U W=5U AS=2.5P AD=2.5P
+ PS=11U PD=11U
M$3 VDD_DIV MI0 \$321 VDD_DIV pfet_03v3 L=0.28U W=2.5U AS=1.25P AD=1.25P PS=6U
+ PD=6U
M$4 VDD_DIV P0 \$321 VDD_DIV pfet_03v3 L=0.28U W=2.5U AS=1.25P AD=1.25P PS=6U
+ PD=6U
M$5 VDD_DIV MO0 \$321 VDD_DIV pfet_03v3 L=0.28U W=2.5U AS=1.25P AD=1.25P PS=6U
+ PD=6U
M$6 VDD_DIV \$291 \$292 VDD_DIV pfet_03v3 L=0.28U W=2.5U AS=1.25P AD=1.25P
+ PS=6U PD=6U
M$7 VDD_DIV \$321 \$292 VDD_DIV pfet_03v3 L=0.28U W=2.5U AS=1.25P AD=1.25P
+ PS=6U PD=6U
M$8 VDD_DIV \$292 \$18 VDD_DIV pfet_03v3 L=0.28U W=2.5U AS=1.25P AD=1.25P PS=6U
+ PD=6U
M$9 VDD_DIV VCO \$19 VDD_DIV pfet_03v3 L=0.28U W=2.5U AS=1.25P AD=1.25P PS=6U
+ PD=6U
M$10 VDD_DIV \$19 \$20 VDD_DIV pfet_03v3 L=0.28U W=2.5U AS=1.25P AD=1.25P PS=6U
+ PD=6U
M$11 \$18 \$20 \$21 VDD_DIV pfet_03v3 L=0.28U W=2.5U AS=1.25P AD=1.25P PS=6U
+ PD=6U
M$12 VDD_DIV \$21 \$22 VDD_DIV pfet_03v3 L=0.28U W=2.5U AS=1.25P AD=1.25P PS=6U
+ PD=6U
M$13 VDD_DIV \$22 \$23 VDD_DIV pfet_03v3 L=0.28U W=2.5U AS=1.25P AD=1.25P PS=6U
+ PD=6U
M$14 \$23 \$19 \$21 VDD_DIV pfet_03v3 L=0.28U W=2.5U AS=1.25P AD=1.25P PS=6U
+ PD=6U
M$15 \$22 \$19 \$24 VDD_DIV pfet_03v3 L=0.28U W=2.5U AS=1.25P AD=1.25P PS=6U
+ PD=6U
M$16 VDD_DIV \$24 \$25 VDD_DIV pfet_03v3 L=0.28U W=2.5U AS=1.25P AD=1.25P PS=6U
+ PD=6U
M$17 VDD_DIV \$25 \$291 VDD_DIV pfet_03v3 L=0.28U W=2.5U AS=1.25P AD=1.25P
+ PS=6U PD=6U
M$18 \$291 \$20 \$24 VDD_DIV pfet_03v3 L=0.28U W=2.5U AS=1.25P AD=1.25P PS=6U
+ PD=6U
M$19 VDD_DIV \$291 CK1 VDD_DIV pfet_03v3 L=0.28U W=5U AS=2.5P AD=2.5P PS=11U
+ PD=11U
M$20 VDD_DIV MI0 \$293 VDD_DIV pfet_03v3 L=0.28U W=2.5U AS=1.25P AD=1.25P PS=6U
+ PD=6U
M$21 VDD_DIV \$25 \$293 VDD_DIV pfet_03v3 L=0.28U W=2.5U AS=1.25P AD=1.25P
+ PS=6U PD=6U
M$22 VDD_DIV \$293 \$28 VDD_DIV pfet_03v3 L=0.28U W=2.5U AS=1.25P AD=1.25P
+ PS=6U PD=6U
M$23 VDD_DIV VCO \$29 VDD_DIV pfet_03v3 L=0.28U W=2.5U AS=1.25P AD=1.25P PS=6U
+ PD=6U
M$24 VDD_DIV \$29 \$30 VDD_DIV pfet_03v3 L=0.28U W=2.5U AS=1.25P AD=1.25P PS=6U
+ PD=6U
M$25 \$28 \$30 \$31 VDD_DIV pfet_03v3 L=0.28U W=2.5U AS=1.25P AD=1.25P PS=6U
+ PD=6U
M$26 VDD_DIV \$31 \$32 VDD_DIV pfet_03v3 L=0.28U W=2.5U AS=1.25P AD=1.25P PS=6U
+ PD=6U
M$27 VDD_DIV \$32 \$33 VDD_DIV pfet_03v3 L=0.28U W=2.5U AS=1.25P AD=1.25P PS=6U
+ PD=6U
M$28 \$33 \$29 \$31 VDD_DIV pfet_03v3 L=0.28U W=2.5U AS=1.25P AD=1.25P PS=6U
+ PD=6U
M$29 \$32 \$29 \$34 VDD_DIV pfet_03v3 L=0.28U W=2.5U AS=1.25P AD=1.25P PS=6U
+ PD=6U
M$30 VDD_DIV \$34 MO0 VDD_DIV pfet_03v3 L=0.28U W=2.5U AS=1.25P AD=1.25P PS=6U
+ PD=6U
M$31 VDD_DIV MO0 \$35 VDD_DIV pfet_03v3 L=0.28U W=2.5U AS=1.25P AD=1.25P PS=6U
+ PD=6U
M$32 \$35 \$30 \$34 VDD_DIV pfet_03v3 L=0.28U W=2.5U AS=1.25P AD=1.25P PS=6U
+ PD=6U
M$33 XNR0_PMID SEL0 NMI0 VDD_DIV pfet_03v3 L=0.28U W=5U AS=2.5P AD=2.5P PS=11U
+ PD=11U
M$34 VDD_DIV NMI0 MI0 VDD_DIV pfet_03v3 L=0.28U W=2.5U AS=1.25P AD=1.25P PS=6U
+ PD=6U
M$35 VDD_DIV CK1 T0 VDD_DIV pfet_03v3 L=0.28U W=2.5U AS=1.25P AD=1.25P PS=6U
+ PD=6U
M$36 VDD_DIV SEL0 T0 VDD_DIV pfet_03v3 L=0.28U W=2.5U AS=1.25P AD=1.25P PS=6U
+ PD=6U
M$37 VDD_DIV MI1 \$322 VDD_DIV pfet_03v3 L=0.28U W=2.5U AS=1.25P AD=1.25P PS=6U
+ PD=6U
M$38 VDD_DIV P1 \$322 VDD_DIV pfet_03v3 L=0.28U W=2.5U AS=1.25P AD=1.25P PS=6U
+ PD=6U
M$39 VDD_DIV MO1 \$322 VDD_DIV pfet_03v3 L=0.28U W=2.5U AS=1.25P AD=1.25P PS=6U
+ PD=6U
M$40 VDD_DIV \$297 \$298 VDD_DIV pfet_03v3 L=0.28U W=2.5U AS=1.25P AD=1.25P
+ PS=6U PD=6U
M$41 VDD_DIV \$322 \$298 VDD_DIV pfet_03v3 L=0.28U W=2.5U AS=1.25P AD=1.25P
+ PS=6U PD=6U
M$42 VDD_DIV \$298 \$40 VDD_DIV pfet_03v3 L=0.28U W=2.5U AS=1.25P AD=1.25P
+ PS=6U PD=6U
M$43 VDD_DIV CK1 \$41 VDD_DIV pfet_03v3 L=0.28U W=2.5U AS=1.25P AD=1.25P PS=6U
+ PD=6U
M$44 VDD_DIV \$41 \$42 VDD_DIV pfet_03v3 L=0.28U W=2.5U AS=1.25P AD=1.25P PS=6U
+ PD=6U
M$45 \$40 \$42 \$43 VDD_DIV pfet_03v3 L=0.28U W=2.5U AS=1.25P AD=1.25P PS=6U
+ PD=6U
M$46 VDD_DIV \$43 \$44 VDD_DIV pfet_03v3 L=0.28U W=2.5U AS=1.25P AD=1.25P PS=6U
+ PD=6U
M$47 VDD_DIV \$44 \$45 VDD_DIV pfet_03v3 L=0.28U W=2.5U AS=1.25P AD=1.25P PS=6U
+ PD=6U
M$48 \$45 \$41 \$43 VDD_DIV pfet_03v3 L=0.28U W=2.5U AS=1.25P AD=1.25P PS=6U
+ PD=6U
M$49 \$44 \$41 \$46 VDD_DIV pfet_03v3 L=0.28U W=2.5U AS=1.25P AD=1.25P PS=6U
+ PD=6U
M$50 VDD_DIV \$46 \$47 VDD_DIV pfet_03v3 L=0.28U W=2.5U AS=1.25P AD=1.25P PS=6U
+ PD=6U
M$51 VDD_DIV \$47 \$297 VDD_DIV pfet_03v3 L=0.28U W=2.5U AS=1.25P AD=1.25P
+ PS=6U PD=6U
M$52 \$297 \$42 \$46 VDD_DIV pfet_03v3 L=0.28U W=2.5U AS=1.25P AD=1.25P PS=6U
+ PD=6U
M$53 VDD_DIV \$297 CK2 VDD_DIV pfet_03v3 L=0.28U W=5U AS=2.5P AD=2.5P PS=11U
+ PD=11U
M$54 VDD_DIV MI1 \$299 VDD_DIV pfet_03v3 L=0.28U W=2.5U AS=1.25P AD=1.25P PS=6U
+ PD=6U
M$55 VDD_DIV \$47 \$299 VDD_DIV pfet_03v3 L=0.28U W=2.5U AS=1.25P AD=1.25P
+ PS=6U PD=6U
M$56 VDD_DIV \$299 \$50 VDD_DIV pfet_03v3 L=0.28U W=2.5U AS=1.25P AD=1.25P
+ PS=6U PD=6U
M$57 VDD_DIV CK1 \$51 VDD_DIV pfet_03v3 L=0.28U W=2.5U AS=1.25P AD=1.25P PS=6U
+ PD=6U
M$58 VDD_DIV \$51 \$52 VDD_DIV pfet_03v3 L=0.28U W=2.5U AS=1.25P AD=1.25P PS=6U
+ PD=6U
M$59 \$50 \$52 \$53 VDD_DIV pfet_03v3 L=0.28U W=2.5U AS=1.25P AD=1.25P PS=6U
+ PD=6U
M$60 VDD_DIV \$53 \$54 VDD_DIV pfet_03v3 L=0.28U W=2.5U AS=1.25P AD=1.25P PS=6U
+ PD=6U
M$61 VDD_DIV \$54 \$55 VDD_DIV pfet_03v3 L=0.28U W=2.5U AS=1.25P AD=1.25P PS=6U
+ PD=6U
M$62 \$55 \$51 \$53 VDD_DIV pfet_03v3 L=0.28U W=2.5U AS=1.25P AD=1.25P PS=6U
+ PD=6U
M$63 \$54 \$51 \$56 VDD_DIV pfet_03v3 L=0.28U W=2.5U AS=1.25P AD=1.25P PS=6U
+ PD=6U
M$64 VDD_DIV \$56 MO1 VDD_DIV pfet_03v3 L=0.28U W=2.5U AS=1.25P AD=1.25P PS=6U
+ PD=6U
M$65 VDD_DIV MO1 \$57 VDD_DIV pfet_03v3 L=0.28U W=2.5U AS=1.25P AD=1.25P PS=6U
+ PD=6U
M$66 \$57 \$52 \$56 VDD_DIV pfet_03v3 L=0.28U W=2.5U AS=1.25P AD=1.25P PS=6U
+ PD=6U
M$67 XNR1_PMID SEL1 NMI1 VDD_DIV pfet_03v3 L=0.28U W=5U AS=2.5P AD=2.5P PS=11U
+ PD=11U
M$68 VDD_DIV NMI1 MI1 VDD_DIV pfet_03v3 L=0.28U W=2.5U AS=1.25P AD=1.25P PS=6U
+ PD=6U
M$69 VDD_DIV CK2 T1 VDD_DIV pfet_03v3 L=0.28U W=2.5U AS=1.25P AD=1.25P PS=6U
+ PD=6U
M$70 VDD_DIV SEL1 T1 VDD_DIV pfet_03v3 L=0.28U W=2.5U AS=1.25P AD=1.25P PS=6U
+ PD=6U
M$71 VDD_DIV MI2 \$323 VDD_DIV pfet_03v3 L=0.28U W=2.5U AS=1.25P AD=1.25P PS=6U
+ PD=6U
M$72 VDD_DIV P2 \$323 VDD_DIV pfet_03v3 L=0.28U W=2.5U AS=1.25P AD=1.25P PS=6U
+ PD=6U
M$73 VDD_DIV MO2 \$323 VDD_DIV pfet_03v3 L=0.28U W=2.5U AS=1.25P AD=1.25P PS=6U
+ PD=6U
M$74 VDD_DIV \$303 \$304 VDD_DIV pfet_03v3 L=0.28U W=2.5U AS=1.25P AD=1.25P
+ PS=6U PD=6U
M$75 VDD_DIV \$323 \$304 VDD_DIV pfet_03v3 L=0.28U W=2.5U AS=1.25P AD=1.25P
+ PS=6U PD=6U
M$76 VDD_DIV \$304 \$62 VDD_DIV pfet_03v3 L=0.28U W=2.5U AS=1.25P AD=1.25P
+ PS=6U PD=6U
M$77 VDD_DIV CK2 \$63 VDD_DIV pfet_03v3 L=0.28U W=2.5U AS=1.25P AD=1.25P PS=6U
+ PD=6U
M$78 VDD_DIV \$63 \$64 VDD_DIV pfet_03v3 L=0.28U W=2.5U AS=1.25P AD=1.25P PS=6U
+ PD=6U
M$79 \$62 \$64 \$65 VDD_DIV pfet_03v3 L=0.28U W=2.5U AS=1.25P AD=1.25P PS=6U
+ PD=6U
M$80 VDD_DIV \$65 \$66 VDD_DIV pfet_03v3 L=0.28U W=2.5U AS=1.25P AD=1.25P PS=6U
+ PD=6U
M$81 VDD_DIV \$66 \$67 VDD_DIV pfet_03v3 L=0.28U W=2.5U AS=1.25P AD=1.25P PS=6U
+ PD=6U
M$82 \$67 \$63 \$65 VDD_DIV pfet_03v3 L=0.28U W=2.5U AS=1.25P AD=1.25P PS=6U
+ PD=6U
M$83 \$66 \$63 \$68 VDD_DIV pfet_03v3 L=0.28U W=2.5U AS=1.25P AD=1.25P PS=6U
+ PD=6U
M$84 VDD_DIV \$68 \$69 VDD_DIV pfet_03v3 L=0.28U W=2.5U AS=1.25P AD=1.25P PS=6U
+ PD=6U
M$85 VDD_DIV \$69 \$303 VDD_DIV pfet_03v3 L=0.28U W=2.5U AS=1.25P AD=1.25P
+ PS=6U PD=6U
M$86 \$303 \$64 \$68 VDD_DIV pfet_03v3 L=0.28U W=2.5U AS=1.25P AD=1.25P PS=6U
+ PD=6U
M$87 VDD_DIV \$303 CK3 VDD_DIV pfet_03v3 L=0.28U W=5U AS=2.5P AD=2.5P PS=11U
+ PD=11U
M$88 VDD_DIV MI2 \$305 VDD_DIV pfet_03v3 L=0.28U W=2.5U AS=1.25P AD=1.25P PS=6U
+ PD=6U
M$89 VDD_DIV \$69 \$305 VDD_DIV pfet_03v3 L=0.28U W=2.5U AS=1.25P AD=1.25P
+ PS=6U PD=6U
M$90 VDD_DIV \$305 \$72 VDD_DIV pfet_03v3 L=0.28U W=2.5U AS=1.25P AD=1.25P
+ PS=6U PD=6U
M$91 VDD_DIV CK2 \$73 VDD_DIV pfet_03v3 L=0.28U W=2.5U AS=1.25P AD=1.25P PS=6U
+ PD=6U
M$92 VDD_DIV \$73 \$74 VDD_DIV pfet_03v3 L=0.28U W=2.5U AS=1.25P AD=1.25P PS=6U
+ PD=6U
M$93 \$72 \$74 \$75 VDD_DIV pfet_03v3 L=0.28U W=2.5U AS=1.25P AD=1.25P PS=6U
+ PD=6U
M$94 VDD_DIV \$75 \$76 VDD_DIV pfet_03v3 L=0.28U W=2.5U AS=1.25P AD=1.25P PS=6U
+ PD=6U
M$95 VDD_DIV \$76 \$77 VDD_DIV pfet_03v3 L=0.28U W=2.5U AS=1.25P AD=1.25P PS=6U
+ PD=6U
M$96 \$77 \$73 \$75 VDD_DIV pfet_03v3 L=0.28U W=2.5U AS=1.25P AD=1.25P PS=6U
+ PD=6U
M$97 \$76 \$73 \$78 VDD_DIV pfet_03v3 L=0.28U W=2.5U AS=1.25P AD=1.25P PS=6U
+ PD=6U
M$98 VDD_DIV \$78 MO2 VDD_DIV pfet_03v3 L=0.28U W=2.5U AS=1.25P AD=1.25P PS=6U
+ PD=6U
M$99 VDD_DIV MO2 \$79 VDD_DIV pfet_03v3 L=0.28U W=2.5U AS=1.25P AD=1.25P PS=6U
+ PD=6U
M$100 \$79 \$74 \$78 VDD_DIV pfet_03v3 L=0.28U W=2.5U AS=1.25P AD=1.25P PS=6U
+ PD=6U
M$101 XNR2_PMID SEL2 NMI2 VDD_DIV pfet_03v3 L=0.28U W=5U AS=2.5P AD=2.5P PS=11U
+ PD=11U
M$102 VDD_DIV NMI2 MI2 VDD_DIV pfet_03v3 L=0.28U W=2.5U AS=1.25P AD=1.25P PS=6U
+ PD=6U
M$103 VDD_DIV CK3 T2 VDD_DIV pfet_03v3 L=0.28U W=2.5U AS=1.25P AD=1.25P PS=6U
+ PD=6U
M$104 VDD_DIV SEL2 T2 VDD_DIV pfet_03v3 L=0.28U W=2.5U AS=1.25P AD=1.25P PS=6U
+ PD=6U
M$105 VDD_DIV T0 MA VDD_DIV pfet_03v3 L=0.28U W=2.5U AS=1.25P AD=1.25P PS=6U
+ PD=6U
M$106 VDD_DIV T1 MA VDD_DIV pfet_03v3 L=0.28U W=2.5U AS=1.25P AD=1.25P PS=6U
+ PD=6U
M$107 VDD_DIV T2 MA VDD_DIV pfet_03v3 L=0.28U W=2.5U AS=1.25P AD=1.25P PS=6U
+ PD=6U
M$108 VDD_DIV MA XMNO_PMID VDD_DIV pfet_03v3 L=0.28U W=5U AS=2.5P AD=2.5P
+ PS=11U PD=11U
M$109 VDD_DIV MO1 XNR0_PMID VDD_DIV pfet_03v3 L=0.28U W=5U AS=2.5P AD=2.5P
+ PS=11U PD=11U
M$110 VDD_DIV MO2 XNR1_PMID VDD_DIV pfet_03v3 L=0.28U W=5U AS=2.5P AD=2.5P
+ PS=11U PD=11U
M$111 VDD_DIV MO3 XNR2_PMID VDD_DIV pfet_03v3 L=0.28U W=5U AS=2.5P AD=2.5P
+ PS=11U PD=11U
M$112 VDD_DIV VCO XFRT_CKB VDD_DIV pfet_03v3 L=0.28U W=2.5U AS=1.25P AD=1.25P
+ PS=6U PD=6U
M$113 VDD_DIV XFRT_CKB XFRT_CKBB VDD_DIV pfet_03v3 L=0.28U W=2.5U AS=1.25P
+ AD=1.25P PS=6U PD=6U
M$114 DIVOUT XFRT_CKBB XFRT_NM VDD_DIV pfet_03v3 L=0.28U W=2.5U AS=1.25P
+ AD=1.25P PS=6U PD=6U
M$115 VDD_DIV XFRT_NM XFRT_NMA VDD_DIV pfet_03v3 L=0.28U W=2.5U AS=1.25P
+ AD=1.25P PS=6U PD=6U
M$116 VDD_DIV XFRT_NMA XFRT_NMB VDD_DIV pfet_03v3 L=0.28U W=2.5U AS=1.25P
+ AD=1.25P PS=6U PD=6U
M$117 XFRT_NMB XFRT_CKB XFRT_NM VDD_DIV pfet_03v3 L=0.28U W=2.5U AS=1.25P
+ AD=1.25P PS=6U PD=6U
M$118 XFRT_NMA XFRT_CKB XFRT_NS VDD_DIV pfet_03v3 L=0.28U W=2.5U AS=1.25P
+ AD=1.25P PS=6U PD=6U
M$119 VDD_DIV XFRT_NS FB VDD_DIV pfet_03v3 L=0.28U W=2.5U AS=1.25P AD=1.25P
+ PS=6U PD=6U
M$120 VDD_DIV FB FBB VDD_DIV pfet_03v3 L=0.28U W=2.5U AS=1.25P AD=1.25P PS=6U
+ PD=6U
M$121 FBB XFRT_CKBB XFRT_NS VDD_DIV pfet_03v3 L=0.28U W=2.5U AS=1.25P AD=1.25P
+ PS=6U PD=6U
M$122 VDD_DIV MI3 \$888 VDD_DIV pfet_03v3 L=0.28U W=2.5U AS=1.25P AD=1.25P
+ PS=6U PD=6U
M$123 VDD_DIV P3 \$888 VDD_DIV pfet_03v3 L=0.28U W=2.5U AS=1.25P AD=1.25P PS=6U
+ PD=6U
M$124 VDD_DIV MO3 \$888 VDD_DIV pfet_03v3 L=0.28U W=2.5U AS=1.25P AD=1.25P
+ PS=6U PD=6U
M$125 VDD_DIV \$613 \$614 VDD_DIV pfet_03v3 L=0.28U W=2.5U AS=1.25P AD=1.25P
+ PS=6U PD=6U
M$126 VDD_DIV \$888 \$614 VDD_DIV pfet_03v3 L=0.28U W=2.5U AS=1.25P AD=1.25P
+ PS=6U PD=6U
M$127 VDD_DIV \$614 \$616 VDD_DIV pfet_03v3 L=0.28U W=2.5U AS=1.25P AD=1.25P
+ PS=6U PD=6U
M$128 VDD_DIV CK3 \$617 VDD_DIV pfet_03v3 L=0.28U W=2.5U AS=1.25P AD=1.25P
+ PS=6U PD=6U
M$129 VDD_DIV \$617 \$618 VDD_DIV pfet_03v3 L=0.28U W=2.5U AS=1.25P AD=1.25P
+ PS=6U PD=6U
M$130 \$616 \$618 \$619 VDD_DIV pfet_03v3 L=0.28U W=2.5U AS=1.25P AD=1.25P
+ PS=6U PD=6U
M$131 VDD_DIV \$619 \$620 VDD_DIV pfet_03v3 L=0.28U W=2.5U AS=1.25P AD=1.25P
+ PS=6U PD=6U
M$132 VDD_DIV \$620 \$621 VDD_DIV pfet_03v3 L=0.28U W=2.5U AS=1.25P AD=1.25P
+ PS=6U PD=6U
M$133 \$621 \$617 \$619 VDD_DIV pfet_03v3 L=0.28U W=2.5U AS=1.25P AD=1.25P
+ PS=6U PD=6U
M$134 \$620 \$617 \$622 VDD_DIV pfet_03v3 L=0.28U W=2.5U AS=1.25P AD=1.25P
+ PS=6U PD=6U
M$135 VDD_DIV \$622 \$623 VDD_DIV pfet_03v3 L=0.28U W=2.5U AS=1.25P AD=1.25P
+ PS=6U PD=6U
M$136 VDD_DIV \$623 \$613 VDD_DIV pfet_03v3 L=0.28U W=2.5U AS=1.25P AD=1.25P
+ PS=6U PD=6U
M$137 \$613 \$618 \$622 VDD_DIV pfet_03v3 L=0.28U W=2.5U AS=1.25P AD=1.25P
+ PS=6U PD=6U
M$138 VDD_DIV \$613 CK4 VDD_DIV pfet_03v3 L=0.28U W=5U AS=2.5P AD=2.5P PS=11U
+ PD=11U
M$139 VDD_DIV MI3 \$624 VDD_DIV pfet_03v3 L=0.28U W=2.5U AS=1.25P AD=1.25P
+ PS=6U PD=6U
M$140 VDD_DIV \$623 \$624 VDD_DIV pfet_03v3 L=0.28U W=2.5U AS=1.25P AD=1.25P
+ PS=6U PD=6U
M$141 VDD_DIV \$624 \$626 VDD_DIV pfet_03v3 L=0.28U W=2.5U AS=1.25P AD=1.25P
+ PS=6U PD=6U
M$142 VDD_DIV CK3 \$627 VDD_DIV pfet_03v3 L=0.28U W=2.5U AS=1.25P AD=1.25P
+ PS=6U PD=6U
M$143 VDD_DIV \$627 \$628 VDD_DIV pfet_03v3 L=0.28U W=2.5U AS=1.25P AD=1.25P
+ PS=6U PD=6U
M$144 \$626 \$628 \$629 VDD_DIV pfet_03v3 L=0.28U W=2.5U AS=1.25P AD=1.25P
+ PS=6U PD=6U
M$145 VDD_DIV \$629 \$630 VDD_DIV pfet_03v3 L=0.28U W=2.5U AS=1.25P AD=1.25P
+ PS=6U PD=6U
M$146 VDD_DIV \$630 \$631 VDD_DIV pfet_03v3 L=0.28U W=2.5U AS=1.25P AD=1.25P
+ PS=6U PD=6U
M$147 \$631 \$627 \$629 VDD_DIV pfet_03v3 L=0.28U W=2.5U AS=1.25P AD=1.25P
+ PS=6U PD=6U
M$148 \$630 \$627 \$632 VDD_DIV pfet_03v3 L=0.28U W=2.5U AS=1.25P AD=1.25P
+ PS=6U PD=6U
M$149 VDD_DIV \$632 MO3 VDD_DIV pfet_03v3 L=0.28U W=2.5U AS=1.25P AD=1.25P
+ PS=6U PD=6U
M$150 VDD_DIV MO3 \$633 VDD_DIV pfet_03v3 L=0.28U W=2.5U AS=1.25P AD=1.25P
+ PS=6U PD=6U
M$151 \$633 \$628 \$632 VDD_DIV pfet_03v3 L=0.28U W=2.5U AS=1.25P AD=1.25P
+ PS=6U PD=6U
M$152 XNR3_PMID SEL3 NMI3 VDD_DIV pfet_03v3 L=0.28U W=5U AS=2.5P AD=2.5P PS=11U
+ PD=11U
M$153 VDD_DIV NMI3 MI3 VDD_DIV pfet_03v3 L=0.28U W=2.5U AS=1.25P AD=1.25P PS=6U
+ PD=6U
M$154 VDD_DIV CK4 T3 VDD_DIV pfet_03v3 L=0.28U W=2.5U AS=1.25P AD=1.25P PS=6U
+ PD=6U
M$155 VDD_DIV SEL3 T3 VDD_DIV pfet_03v3 L=0.28U W=2.5U AS=1.25P AD=1.25P PS=6U
+ PD=6U
M$156 VDD_DIV MI4 \$890 VDD_DIV pfet_03v3 L=0.28U W=2.5U AS=1.25P AD=1.25P
+ PS=6U PD=6U
M$157 VDD_DIV P4 \$890 VDD_DIV pfet_03v3 L=0.28U W=2.5U AS=1.25P AD=1.25P PS=6U
+ PD=6U
M$158 VDD_DIV MO4 \$890 VDD_DIV pfet_03v3 L=0.28U W=2.5U AS=1.25P AD=1.25P
+ PS=6U PD=6U
M$159 VDD_DIV \$638 \$639 VDD_DIV pfet_03v3 L=0.28U W=2.5U AS=1.25P AD=1.25P
+ PS=6U PD=6U
M$160 VDD_DIV \$890 \$639 VDD_DIV pfet_03v3 L=0.28U W=2.5U AS=1.25P AD=1.25P
+ PS=6U PD=6U
M$161 VDD_DIV \$639 \$641 VDD_DIV pfet_03v3 L=0.28U W=2.5U AS=1.25P AD=1.25P
+ PS=6U PD=6U
M$162 VDD_DIV CK4 \$642 VDD_DIV pfet_03v3 L=0.28U W=2.5U AS=1.25P AD=1.25P
+ PS=6U PD=6U
M$163 VDD_DIV \$642 \$643 VDD_DIV pfet_03v3 L=0.28U W=2.5U AS=1.25P AD=1.25P
+ PS=6U PD=6U
M$164 \$641 \$643 \$644 VDD_DIV pfet_03v3 L=0.28U W=2.5U AS=1.25P AD=1.25P
+ PS=6U PD=6U
M$165 VDD_DIV \$644 \$645 VDD_DIV pfet_03v3 L=0.28U W=2.5U AS=1.25P AD=1.25P
+ PS=6U PD=6U
M$166 VDD_DIV \$645 \$646 VDD_DIV pfet_03v3 L=0.28U W=2.5U AS=1.25P AD=1.25P
+ PS=6U PD=6U
M$167 \$646 \$642 \$644 VDD_DIV pfet_03v3 L=0.28U W=2.5U AS=1.25P AD=1.25P
+ PS=6U PD=6U
M$168 \$645 \$642 \$647 VDD_DIV pfet_03v3 L=0.28U W=2.5U AS=1.25P AD=1.25P
+ PS=6U PD=6U
M$169 VDD_DIV \$647 \$648 VDD_DIV pfet_03v3 L=0.28U W=2.5U AS=1.25P AD=1.25P
+ PS=6U PD=6U
M$170 VDD_DIV \$648 \$638 VDD_DIV pfet_03v3 L=0.28U W=2.5U AS=1.25P AD=1.25P
+ PS=6U PD=6U
M$171 \$638 \$643 \$647 VDD_DIV pfet_03v3 L=0.28U W=2.5U AS=1.25P AD=1.25P
+ PS=6U PD=6U
M$172 VDD_DIV \$638 CK5 VDD_DIV pfet_03v3 L=0.28U W=5U AS=2.5P AD=2.5P PS=11U
+ PD=11U
M$173 VDD_DIV MI4 \$651 VDD_DIV pfet_03v3 L=0.28U W=2.5U AS=1.25P AD=1.25P
+ PS=6U PD=6U
M$174 VDD_DIV \$648 \$651 VDD_DIV pfet_03v3 L=0.28U W=2.5U AS=1.25P AD=1.25P
+ PS=6U PD=6U
M$175 VDD_DIV \$651 \$652 VDD_DIV pfet_03v3 L=0.28U W=2.5U AS=1.25P AD=1.25P
+ PS=6U PD=6U
M$176 VDD_DIV CK4 \$653 VDD_DIV pfet_03v3 L=0.28U W=2.5U AS=1.25P AD=1.25P
+ PS=6U PD=6U
M$177 VDD_DIV \$653 \$654 VDD_DIV pfet_03v3 L=0.28U W=2.5U AS=1.25P AD=1.25P
+ PS=6U PD=6U
M$178 \$652 \$654 \$655 VDD_DIV pfet_03v3 L=0.28U W=2.5U AS=1.25P AD=1.25P
+ PS=6U PD=6U
M$179 VDD_DIV \$655 \$656 VDD_DIV pfet_03v3 L=0.28U W=2.5U AS=1.25P AD=1.25P
+ PS=6U PD=6U
M$180 VDD_DIV \$656 \$657 VDD_DIV pfet_03v3 L=0.28U W=2.5U AS=1.25P AD=1.25P
+ PS=6U PD=6U
M$181 \$657 \$653 \$655 VDD_DIV pfet_03v3 L=0.28U W=2.5U AS=1.25P AD=1.25P
+ PS=6U PD=6U
M$182 \$656 \$653 \$658 VDD_DIV pfet_03v3 L=0.28U W=2.5U AS=1.25P AD=1.25P
+ PS=6U PD=6U
M$183 VDD_DIV \$658 MO4 VDD_DIV pfet_03v3 L=0.28U W=2.5U AS=1.25P AD=1.25P
+ PS=6U PD=6U
M$184 VDD_DIV MO4 \$659 VDD_DIV pfet_03v3 L=0.28U W=2.5U AS=1.25P AD=1.25P
+ PS=6U PD=6U
M$185 \$659 \$654 \$658 VDD_DIV pfet_03v3 L=0.28U W=2.5U AS=1.25P AD=1.25P
+ PS=6U PD=6U
M$186 XNR4_PMID SEL4 NMI4 VDD_DIV pfet_03v3 L=0.28U W=5U AS=2.5P AD=2.5P PS=11U
+ PD=11U
M$187 VDD_DIV NMI4 MI4 VDD_DIV pfet_03v3 L=0.28U W=2.5U AS=1.25P AD=1.25P PS=6U
+ PD=6U
M$188 VDD_DIV CK5 T4 VDD_DIV pfet_03v3 L=0.28U W=2.5U AS=1.25P AD=1.25P PS=6U
+ PD=6U
M$189 VDD_DIV SEL4 T4 VDD_DIV pfet_03v3 L=0.28U W=2.5U AS=1.25P AD=1.25P PS=6U
+ PD=6U
M$190 VDD_DIV SEL5 \$892 VDD_DIV pfet_03v3 L=0.28U W=2.5U AS=1.25P AD=1.25P
+ PS=6U PD=6U
M$191 VDD_DIV P5 \$892 VDD_DIV pfet_03v3 L=0.28U W=2.5U AS=1.25P AD=1.25P PS=6U
+ PD=6U
M$192 VDD_DIV MO5 \$892 VDD_DIV pfet_03v3 L=0.28U W=2.5U AS=1.25P AD=1.25P
+ PS=6U PD=6U
M$193 VDD_DIV \$663 \$664 VDD_DIV pfet_03v3 L=0.28U W=2.5U AS=1.25P AD=1.25P
+ PS=6U PD=6U
M$194 VDD_DIV \$892 \$664 VDD_DIV pfet_03v3 L=0.28U W=2.5U AS=1.25P AD=1.25P
+ PS=6U PD=6U
M$195 VDD_DIV \$664 \$666 VDD_DIV pfet_03v3 L=0.28U W=2.5U AS=1.25P AD=1.25P
+ PS=6U PD=6U
M$196 VDD_DIV CK5 \$667 VDD_DIV pfet_03v3 L=0.28U W=2.5U AS=1.25P AD=1.25P
+ PS=6U PD=6U
M$197 VDD_DIV \$667 \$668 VDD_DIV pfet_03v3 L=0.28U W=2.5U AS=1.25P AD=1.25P
+ PS=6U PD=6U
M$198 \$666 \$668 \$669 VDD_DIV pfet_03v3 L=0.28U W=2.5U AS=1.25P AD=1.25P
+ PS=6U PD=6U
M$199 VDD_DIV \$669 \$670 VDD_DIV pfet_03v3 L=0.28U W=2.5U AS=1.25P AD=1.25P
+ PS=6U PD=6U
M$200 VDD_DIV \$670 \$671 VDD_DIV pfet_03v3 L=0.28U W=2.5U AS=1.25P AD=1.25P
+ PS=6U PD=6U
M$201 \$671 \$667 \$669 VDD_DIV pfet_03v3 L=0.28U W=2.5U AS=1.25P AD=1.25P
+ PS=6U PD=6U
M$202 \$670 \$667 \$672 VDD_DIV pfet_03v3 L=0.28U W=2.5U AS=1.25P AD=1.25P
+ PS=6U PD=6U
M$203 VDD_DIV \$672 \$673 VDD_DIV pfet_03v3 L=0.28U W=2.5U AS=1.25P AD=1.25P
+ PS=6U PD=6U
M$204 VDD_DIV \$673 \$663 VDD_DIV pfet_03v3 L=0.28U W=2.5U AS=1.25P AD=1.25P
+ PS=6U PD=6U
M$205 \$663 \$668 \$672 VDD_DIV pfet_03v3 L=0.28U W=2.5U AS=1.25P AD=1.25P
+ PS=6U PD=6U
M$206 VDD_DIV \$663 CK6 VDD_DIV pfet_03v3 L=0.28U W=5U AS=2.5P AD=2.5P PS=11U
+ PD=11U
M$207 VDD_DIV SEL5 \$674 VDD_DIV pfet_03v3 L=0.28U W=2.5U AS=1.25P AD=1.25P
+ PS=6U PD=6U
M$208 VDD_DIV \$673 \$674 VDD_DIV pfet_03v3 L=0.28U W=2.5U AS=1.25P AD=1.25P
+ PS=6U PD=6U
M$209 VDD_DIV \$674 \$676 VDD_DIV pfet_03v3 L=0.28U W=2.5U AS=1.25P AD=1.25P
+ PS=6U PD=6U
M$210 VDD_DIV CK5 \$677 VDD_DIV pfet_03v3 L=0.28U W=2.5U AS=1.25P AD=1.25P
+ PS=6U PD=6U
M$211 VDD_DIV \$677 \$678 VDD_DIV pfet_03v3 L=0.28U W=2.5U AS=1.25P AD=1.25P
+ PS=6U PD=6U
M$212 \$676 \$678 \$679 VDD_DIV pfet_03v3 L=0.28U W=2.5U AS=1.25P AD=1.25P
+ PS=6U PD=6U
M$213 VDD_DIV \$679 \$680 VDD_DIV pfet_03v3 L=0.28U W=2.5U AS=1.25P AD=1.25P
+ PS=6U PD=6U
M$214 VDD_DIV \$680 \$681 VDD_DIV pfet_03v3 L=0.28U W=2.5U AS=1.25P AD=1.25P
+ PS=6U PD=6U
M$215 \$681 \$677 \$679 VDD_DIV pfet_03v3 L=0.28U W=2.5U AS=1.25P AD=1.25P
+ PS=6U PD=6U
M$216 \$680 \$677 \$682 VDD_DIV pfet_03v3 L=0.28U W=2.5U AS=1.25P AD=1.25P
+ PS=6U PD=6U
M$217 VDD_DIV \$682 MO5 VDD_DIV pfet_03v3 L=0.28U W=2.5U AS=1.25P AD=1.25P
+ PS=6U PD=6U
M$218 VDD_DIV MO5 \$683 VDD_DIV pfet_03v3 L=0.28U W=2.5U AS=1.25P AD=1.25P
+ PS=6U PD=6U
M$219 \$683 \$678 \$682 VDD_DIV pfet_03v3 L=0.28U W=2.5U AS=1.25P AD=1.25P
+ PS=6U PD=6U
M$220 VDD_DIV CK6 T5 VDD_DIV pfet_03v3 L=0.28U W=2.5U AS=1.25P AD=1.25P PS=6U
+ PD=6U
M$221 VDD_DIV SEL5 T5 VDD_DIV pfet_03v3 L=0.28U W=2.5U AS=1.25P AD=1.25P PS=6U
+ PD=6U
M$222 VDD_DIV T3 MB VDD_DIV pfet_03v3 L=0.28U W=2.5U AS=1.25P AD=1.25P PS=6U
+ PD=6U
M$223 VDD_DIV T4 MB VDD_DIV pfet_03v3 L=0.28U W=2.5U AS=1.25P AD=1.25P PS=6U
+ PD=6U
M$224 VDD_DIV T5 MB VDD_DIV pfet_03v3 L=0.28U W=2.5U AS=1.25P AD=1.25P PS=6U
+ PD=6U
M$225 VDD_DIV MO4 XNR3_PMID VDD_DIV pfet_03v3 L=0.28U W=5U AS=2.5P AD=2.5P
+ PS=11U PD=11U
M$226 VDD_DIV MO5 XNR4_PMID VDD_DIV pfet_03v3 L=0.28U W=5U AS=2.5P AD=2.5P
+ PS=11U PD=11U
M$227 DIVOUTB MA VSS VSS nfet_03v3 L=0.28U W=1U AS=0.5P AD=0.5P PS=3U PD=3U
M$228 DIVOUTB MB VSS VSS nfet_03v3 L=0.28U W=1U AS=0.5P AD=0.5P PS=3U PD=3U
M$229 DIVOUT DIVOUTB VSS VSS nfet_03v3 L=0.28U W=2U AS=1P AD=1P PS=5U PD=5U
M$230 \$16 MO0 VSS VSS nfet_03v3 L=0.28U W=3U AS=1.5P AD=1.5P PS=7U PD=7U
M$231 \$17 \$321 VSS VSS nfet_03v3 L=0.28U W=2U AS=1P AD=1P PS=5U PD=5U
M$232 \$18 \$292 VSS VSS nfet_03v3 L=0.28U W=1U AS=0.5P AD=0.5P PS=3U PD=3U
M$233 \$19 VCO VSS VSS nfet_03v3 L=0.28U W=1U AS=0.5P AD=0.5P PS=3U PD=3U
M$234 \$20 \$19 VSS VSS nfet_03v3 L=0.28U W=1U AS=0.5P AD=0.5P PS=3U PD=3U
M$235 \$21 \$19 \$18 VSS nfet_03v3 L=0.28U W=1U AS=0.5P AD=0.5P PS=3U PD=3U
M$236 \$22 \$21 VSS VSS nfet_03v3 L=0.28U W=1U AS=0.5P AD=0.5P PS=3U PD=3U
M$237 \$23 \$22 VSS VSS nfet_03v3 L=0.28U W=1U AS=0.5P AD=0.5P PS=3U PD=3U
M$238 \$21 \$20 \$23 VSS nfet_03v3 L=0.28U W=1U AS=0.5P AD=0.5P PS=3U PD=3U
M$239 \$24 \$20 \$22 VSS nfet_03v3 L=0.28U W=1U AS=0.5P AD=0.5P PS=3U PD=3U
M$240 \$25 \$24 VSS VSS nfet_03v3 L=0.28U W=1U AS=0.5P AD=0.5P PS=3U PD=3U
M$241 \$291 \$25 VSS VSS nfet_03v3 L=0.28U W=1U AS=0.5P AD=0.5P PS=3U PD=3U
M$242 \$24 \$19 \$291 VSS nfet_03v3 L=0.28U W=1U AS=0.5P AD=0.5P PS=3U PD=3U
M$243 CK1 \$291 VSS VSS nfet_03v3 L=0.28U W=2U AS=1P AD=1P PS=5U PD=5U
M$244 \$27 \$25 VSS VSS nfet_03v3 L=0.28U W=2U AS=1P AD=1P PS=5U PD=5U
M$245 \$28 \$293 VSS VSS nfet_03v3 L=0.28U W=1U AS=0.5P AD=0.5P PS=3U PD=3U
M$246 \$29 VCO VSS VSS nfet_03v3 L=0.28U W=1U AS=0.5P AD=0.5P PS=3U PD=3U
M$247 \$30 \$29 VSS VSS nfet_03v3 L=0.28U W=1U AS=0.5P AD=0.5P PS=3U PD=3U
M$248 \$31 \$29 \$28 VSS nfet_03v3 L=0.28U W=1U AS=0.5P AD=0.5P PS=3U PD=3U
M$249 \$32 \$31 VSS VSS nfet_03v3 L=0.28U W=1U AS=0.5P AD=0.5P PS=3U PD=3U
M$250 \$33 \$32 VSS VSS nfet_03v3 L=0.28U W=1U AS=0.5P AD=0.5P PS=3U PD=3U
M$251 \$31 \$30 \$33 VSS nfet_03v3 L=0.28U W=1U AS=0.5P AD=0.5P PS=3U PD=3U
M$252 \$34 \$30 \$32 VSS nfet_03v3 L=0.28U W=1U AS=0.5P AD=0.5P PS=3U PD=3U
M$253 MO0 \$34 VSS VSS nfet_03v3 L=0.28U W=1U AS=0.5P AD=0.5P PS=3U PD=3U
M$254 \$35 MO0 VSS VSS nfet_03v3 L=0.28U W=1U AS=0.5P AD=0.5P PS=3U PD=3U
M$255 \$34 \$29 \$35 VSS nfet_03v3 L=0.28U W=1U AS=0.5P AD=0.5P PS=3U PD=3U
M$256 NMI0 MO1 VSS VSS nfet_03v3 L=0.28U W=1U AS=0.5P AD=0.5P PS=3U PD=3U
M$257 NMI0 SEL0 VSS VSS nfet_03v3 L=0.28U W=1U AS=0.5P AD=0.5P PS=3U PD=3U
M$258 MI0 NMI0 VSS VSS nfet_03v3 L=0.28U W=1U AS=0.5P AD=0.5P PS=3U PD=3U
M$259 XM0_NMID SEL0 VSS VSS nfet_03v3 L=0.28U W=2U AS=1P AD=1P PS=5U PD=5U
M$260 \$38 MO1 VSS VSS nfet_03v3 L=0.28U W=3U AS=1.5P AD=1.5P PS=7U PD=7U
M$261 \$39 \$322 VSS VSS nfet_03v3 L=0.28U W=2U AS=1P AD=1P PS=5U PD=5U
M$262 \$40 \$298 VSS VSS nfet_03v3 L=0.28U W=1U AS=0.5P AD=0.5P PS=3U PD=3U
M$263 \$41 CK1 VSS VSS nfet_03v3 L=0.28U W=1U AS=0.5P AD=0.5P PS=3U PD=3U
M$264 \$42 \$41 VSS VSS nfet_03v3 L=0.28U W=1U AS=0.5P AD=0.5P PS=3U PD=3U
M$265 \$43 \$41 \$40 VSS nfet_03v3 L=0.28U W=1U AS=0.5P AD=0.5P PS=3U PD=3U
M$266 \$44 \$43 VSS VSS nfet_03v3 L=0.28U W=1U AS=0.5P AD=0.5P PS=3U PD=3U
M$267 \$45 \$44 VSS VSS nfet_03v3 L=0.28U W=1U AS=0.5P AD=0.5P PS=3U PD=3U
M$268 \$43 \$42 \$45 VSS nfet_03v3 L=0.28U W=1U AS=0.5P AD=0.5P PS=3U PD=3U
M$269 \$46 \$42 \$44 VSS nfet_03v3 L=0.28U W=1U AS=0.5P AD=0.5P PS=3U PD=3U
M$270 \$47 \$46 VSS VSS nfet_03v3 L=0.28U W=1U AS=0.5P AD=0.5P PS=3U PD=3U
M$271 \$297 \$47 VSS VSS nfet_03v3 L=0.28U W=1U AS=0.5P AD=0.5P PS=3U PD=3U
M$272 \$46 \$41 \$297 VSS nfet_03v3 L=0.28U W=1U AS=0.5P AD=0.5P PS=3U PD=3U
M$273 CK2 \$297 VSS VSS nfet_03v3 L=0.28U W=2U AS=1P AD=1P PS=5U PD=5U
M$274 \$49 \$47 VSS VSS nfet_03v3 L=0.28U W=2U AS=1P AD=1P PS=5U PD=5U
M$275 \$50 \$299 VSS VSS nfet_03v3 L=0.28U W=1U AS=0.5P AD=0.5P PS=3U PD=3U
M$276 \$51 CK1 VSS VSS nfet_03v3 L=0.28U W=1U AS=0.5P AD=0.5P PS=3U PD=3U
M$277 \$52 \$51 VSS VSS nfet_03v3 L=0.28U W=1U AS=0.5P AD=0.5P PS=3U PD=3U
M$278 \$53 \$51 \$50 VSS nfet_03v3 L=0.28U W=1U AS=0.5P AD=0.5P PS=3U PD=3U
M$279 \$54 \$53 VSS VSS nfet_03v3 L=0.28U W=1U AS=0.5P AD=0.5P PS=3U PD=3U
M$280 \$55 \$54 VSS VSS nfet_03v3 L=0.28U W=1U AS=0.5P AD=0.5P PS=3U PD=3U
M$281 \$53 \$52 \$55 VSS nfet_03v3 L=0.28U W=1U AS=0.5P AD=0.5P PS=3U PD=3U
M$282 \$56 \$52 \$54 VSS nfet_03v3 L=0.28U W=1U AS=0.5P AD=0.5P PS=3U PD=3U
M$283 MO1 \$56 VSS VSS nfet_03v3 L=0.28U W=1U AS=0.5P AD=0.5P PS=3U PD=3U
M$284 \$57 MO1 VSS VSS nfet_03v3 L=0.28U W=1U AS=0.5P AD=0.5P PS=3U PD=3U
M$285 \$56 \$51 \$57 VSS nfet_03v3 L=0.28U W=1U AS=0.5P AD=0.5P PS=3U PD=3U
M$286 NMI1 MO2 VSS VSS nfet_03v3 L=0.28U W=1U AS=0.5P AD=0.5P PS=3U PD=3U
M$287 NMI1 SEL1 VSS VSS nfet_03v3 L=0.28U W=1U AS=0.5P AD=0.5P PS=3U PD=3U
M$288 MI1 NMI1 VSS VSS nfet_03v3 L=0.28U W=1U AS=0.5P AD=0.5P PS=3U PD=3U
M$289 XM1_NMID SEL1 VSS VSS nfet_03v3 L=0.28U W=2U AS=1P AD=1P PS=5U PD=5U
M$290 \$60 MO2 VSS VSS nfet_03v3 L=0.28U W=3U AS=1.5P AD=1.5P PS=7U PD=7U
M$291 \$61 \$323 VSS VSS nfet_03v3 L=0.28U W=2U AS=1P AD=1P PS=5U PD=5U
M$292 \$62 \$304 VSS VSS nfet_03v3 L=0.28U W=1U AS=0.5P AD=0.5P PS=3U PD=3U
M$293 \$63 CK2 VSS VSS nfet_03v3 L=0.28U W=1U AS=0.5P AD=0.5P PS=3U PD=3U
M$294 \$64 \$63 VSS VSS nfet_03v3 L=0.28U W=1U AS=0.5P AD=0.5P PS=3U PD=3U
M$295 \$65 \$63 \$62 VSS nfet_03v3 L=0.28U W=1U AS=0.5P AD=0.5P PS=3U PD=3U
M$296 \$66 \$65 VSS VSS nfet_03v3 L=0.28U W=1U AS=0.5P AD=0.5P PS=3U PD=3U
M$297 \$67 \$66 VSS VSS nfet_03v3 L=0.28U W=1U AS=0.5P AD=0.5P PS=3U PD=3U
M$298 \$65 \$64 \$67 VSS nfet_03v3 L=0.28U W=1U AS=0.5P AD=0.5P PS=3U PD=3U
M$299 \$68 \$64 \$66 VSS nfet_03v3 L=0.28U W=1U AS=0.5P AD=0.5P PS=3U PD=3U
M$300 \$69 \$68 VSS VSS nfet_03v3 L=0.28U W=1U AS=0.5P AD=0.5P PS=3U PD=3U
M$301 \$303 \$69 VSS VSS nfet_03v3 L=0.28U W=1U AS=0.5P AD=0.5P PS=3U PD=3U
M$302 \$68 \$63 \$303 VSS nfet_03v3 L=0.28U W=1U AS=0.5P AD=0.5P PS=3U PD=3U
M$303 CK3 \$303 VSS VSS nfet_03v3 L=0.28U W=2U AS=1P AD=1P PS=5U PD=5U
M$304 \$71 \$69 VSS VSS nfet_03v3 L=0.28U W=2U AS=1P AD=1P PS=5U PD=5U
M$305 \$72 \$305 VSS VSS nfet_03v3 L=0.28U W=1U AS=0.5P AD=0.5P PS=3U PD=3U
M$306 \$73 CK2 VSS VSS nfet_03v3 L=0.28U W=1U AS=0.5P AD=0.5P PS=3U PD=3U
M$307 \$74 \$73 VSS VSS nfet_03v3 L=0.28U W=1U AS=0.5P AD=0.5P PS=3U PD=3U
M$308 \$75 \$73 \$72 VSS nfet_03v3 L=0.28U W=1U AS=0.5P AD=0.5P PS=3U PD=3U
M$309 \$76 \$75 VSS VSS nfet_03v3 L=0.28U W=1U AS=0.5P AD=0.5P PS=3U PD=3U
M$310 \$77 \$76 VSS VSS nfet_03v3 L=0.28U W=1U AS=0.5P AD=0.5P PS=3U PD=3U
M$311 \$75 \$74 \$77 VSS nfet_03v3 L=0.28U W=1U AS=0.5P AD=0.5P PS=3U PD=3U
M$312 \$78 \$74 \$76 VSS nfet_03v3 L=0.28U W=1U AS=0.5P AD=0.5P PS=3U PD=3U
M$313 MO2 \$78 VSS VSS nfet_03v3 L=0.28U W=1U AS=0.5P AD=0.5P PS=3U PD=3U
M$314 \$79 MO2 VSS VSS nfet_03v3 L=0.28U W=1U AS=0.5P AD=0.5P PS=3U PD=3U
M$315 \$78 \$73 \$79 VSS nfet_03v3 L=0.28U W=1U AS=0.5P AD=0.5P PS=3U PD=3U
M$316 NMI2 MO3 VSS VSS nfet_03v3 L=0.28U W=1U AS=0.5P AD=0.5P PS=3U PD=3U
M$317 NMI2 SEL2 VSS VSS nfet_03v3 L=0.28U W=1U AS=0.5P AD=0.5P PS=3U PD=3U
M$318 MI2 NMI2 VSS VSS nfet_03v3 L=0.28U W=1U AS=0.5P AD=0.5P PS=3U PD=3U
M$319 XM2_NMID SEL2 VSS VSS nfet_03v3 L=0.28U W=2U AS=1P AD=1P PS=5U PD=5U
M$320 XMA_NM2 T2 VSS VSS nfet_03v3 L=0.28U W=3U AS=1.5P AD=1.5P PS=7U PD=7U
M$321 \$321 MI0 \$290 VSS nfet_03v3 L=0.28U W=3U AS=1.5P AD=1.5P PS=7U PD=7U
M$322 \$290 P0 \$16 VSS nfet_03v3 L=0.28U W=3U AS=1.5P AD=1.5P PS=7U PD=7U
M$323 \$292 \$291 \$17 VSS nfet_03v3 L=0.28U W=2U AS=1P AD=1P PS=5U PD=5U
M$324 \$293 MI0 \$27 VSS nfet_03v3 L=0.28U W=2U AS=1P AD=1P PS=5U PD=5U
M$325 T0 CK1 XM0_NMID VSS nfet_03v3 L=0.28U W=2U AS=1P AD=1P PS=5U PD=5U
M$326 \$322 MI1 \$296 VSS nfet_03v3 L=0.28U W=3U AS=1.5P AD=1.5P PS=7U PD=7U
M$327 \$296 P1 \$38 VSS nfet_03v3 L=0.28U W=3U AS=1.5P AD=1.5P PS=7U PD=7U
M$328 \$298 \$297 \$39 VSS nfet_03v3 L=0.28U W=2U AS=1P AD=1P PS=5U PD=5U
M$329 \$299 MI1 \$49 VSS nfet_03v3 L=0.28U W=2U AS=1P AD=1P PS=5U PD=5U
M$330 T1 CK2 XM1_NMID VSS nfet_03v3 L=0.28U W=2U AS=1P AD=1P PS=5U PD=5U
M$331 \$302 P2 \$60 VSS nfet_03v3 L=0.28U W=3U AS=1.5P AD=1.5P PS=7U PD=7U
M$332 \$323 MI2 \$302 VSS nfet_03v3 L=0.28U W=3U AS=1.5P AD=1.5P PS=7U PD=7U
M$333 \$304 \$303 \$61 VSS nfet_03v3 L=0.28U W=2U AS=1P AD=1P PS=5U PD=5U
M$334 \$305 MI2 \$71 VSS nfet_03v3 L=0.28U W=2U AS=1P AD=1P PS=5U PD=5U
M$335 T2 CK3 XM2_NMID VSS nfet_03v3 L=0.28U W=2U AS=1P AD=1P PS=5U PD=5U
M$336 MA T0 XMA_NM1 VSS nfet_03v3 L=0.28U W=3U AS=1.5P AD=1.5P PS=7U PD=7U
M$337 XMA_NM1 T1 XMA_NM2 VSS nfet_03v3 L=0.28U W=3U AS=1.5P AD=1.5P PS=7U PD=7U
M$338 XFRT_CKB VCO VSS VSS nfet_03v3 L=0.28U W=1U AS=0.5P AD=0.5P PS=3U PD=3U
M$339 XFRT_CKBB XFRT_CKB VSS VSS nfet_03v3 L=0.28U W=1U AS=0.5P AD=0.5P PS=3U
+ PD=3U
M$340 XFRT_NM XFRT_CKB DIVOUT VSS nfet_03v3 L=0.28U W=1U AS=0.5P AD=0.5P PS=3U
+ PD=3U
M$341 XFRT_NMA XFRT_NM VSS VSS nfet_03v3 L=0.28U W=1U AS=0.5P AD=0.5P PS=3U
+ PD=3U
M$342 XFRT_NMB XFRT_NMA VSS VSS nfet_03v3 L=0.28U W=1U AS=0.5P AD=0.5P PS=3U
+ PD=3U
M$343 XFRT_NM XFRT_CKBB XFRT_NMB VSS nfet_03v3 L=0.28U W=1U AS=0.5P AD=0.5P
+ PS=3U PD=3U
M$344 XFRT_NS XFRT_CKBB XFRT_NMA VSS nfet_03v3 L=0.28U W=1U AS=0.5P AD=0.5P
+ PS=3U PD=3U
M$345 FB XFRT_NS VSS VSS nfet_03v3 L=0.28U W=1U AS=0.5P AD=0.5P PS=3U PD=3U
M$346 FBB FB VSS VSS nfet_03v3 L=0.28U W=1U AS=0.5P AD=0.5P PS=3U PD=3U
M$347 XFRT_NS XFRT_CKB FBB VSS nfet_03v3 L=0.28U W=1U AS=0.5P AD=0.5P PS=3U
+ PD=3U
M$348 \$355 MO3 VSS VSS nfet_03v3 L=0.28U W=3U AS=1.5P AD=1.5P PS=7U PD=7U
M$349 \$615 \$888 VSS VSS nfet_03v3 L=0.28U W=2U AS=1P AD=1P PS=5U PD=5U
M$350 \$616 \$614 VSS VSS nfet_03v3 L=0.28U W=1U AS=0.5P AD=0.5P PS=3U PD=3U
M$351 \$617 CK3 VSS VSS nfet_03v3 L=0.28U W=1U AS=0.5P AD=0.5P PS=3U PD=3U
M$352 \$618 \$617 VSS VSS nfet_03v3 L=0.28U W=1U AS=0.5P AD=0.5P PS=3U PD=3U
M$353 \$619 \$617 \$616 VSS nfet_03v3 L=0.28U W=1U AS=0.5P AD=0.5P PS=3U PD=3U
M$354 \$620 \$619 VSS VSS nfet_03v3 L=0.28U W=1U AS=0.5P AD=0.5P PS=3U PD=3U
M$355 \$621 \$620 VSS VSS nfet_03v3 L=0.28U W=1U AS=0.5P AD=0.5P PS=3U PD=3U
M$356 \$619 \$618 \$621 VSS nfet_03v3 L=0.28U W=1U AS=0.5P AD=0.5P PS=3U PD=3U
M$357 \$622 \$618 \$620 VSS nfet_03v3 L=0.28U W=1U AS=0.5P AD=0.5P PS=3U PD=3U
M$358 \$623 \$622 VSS VSS nfet_03v3 L=0.28U W=1U AS=0.5P AD=0.5P PS=3U PD=3U
M$359 \$613 \$623 VSS VSS nfet_03v3 L=0.28U W=1U AS=0.5P AD=0.5P PS=3U PD=3U
M$360 \$622 \$617 \$613 VSS nfet_03v3 L=0.28U W=1U AS=0.5P AD=0.5P PS=3U PD=3U
M$361 CK4 \$613 VSS VSS nfet_03v3 L=0.28U W=2U AS=1P AD=1P PS=5U PD=5U
M$362 \$625 \$623 VSS VSS nfet_03v3 L=0.28U W=2U AS=1P AD=1P PS=5U PD=5U
M$363 \$626 \$624 VSS VSS nfet_03v3 L=0.28U W=1U AS=0.5P AD=0.5P PS=3U PD=3U
M$364 \$627 CK3 VSS VSS nfet_03v3 L=0.28U W=1U AS=0.5P AD=0.5P PS=3U PD=3U
M$365 \$628 \$627 VSS VSS nfet_03v3 L=0.28U W=1U AS=0.5P AD=0.5P PS=3U PD=3U
M$366 \$629 \$627 \$626 VSS nfet_03v3 L=0.28U W=1U AS=0.5P AD=0.5P PS=3U PD=3U
M$367 \$630 \$629 VSS VSS nfet_03v3 L=0.28U W=1U AS=0.5P AD=0.5P PS=3U PD=3U
M$368 \$631 \$630 VSS VSS nfet_03v3 L=0.28U W=1U AS=0.5P AD=0.5P PS=3U PD=3U
M$369 \$629 \$628 \$631 VSS nfet_03v3 L=0.28U W=1U AS=0.5P AD=0.5P PS=3U PD=3U
M$370 \$632 \$628 \$630 VSS nfet_03v3 L=0.28U W=1U AS=0.5P AD=0.5P PS=3U PD=3U
M$371 MO3 \$632 VSS VSS nfet_03v3 L=0.28U W=1U AS=0.5P AD=0.5P PS=3U PD=3U
M$372 \$633 MO3 VSS VSS nfet_03v3 L=0.28U W=1U AS=0.5P AD=0.5P PS=3U PD=3U
M$373 \$632 \$627 \$633 VSS nfet_03v3 L=0.28U W=1U AS=0.5P AD=0.5P PS=3U PD=3U
M$374 NMI3 MO4 VSS VSS nfet_03v3 L=0.28U W=1U AS=0.5P AD=0.5P PS=3U PD=3U
M$375 NMI3 SEL3 VSS VSS nfet_03v3 L=0.28U W=1U AS=0.5P AD=0.5P PS=3U PD=3U
M$376 MI3 NMI3 VSS VSS nfet_03v3 L=0.28U W=1U AS=0.5P AD=0.5P PS=3U PD=3U
M$377 XM3_NMID SEL3 VSS VSS nfet_03v3 L=0.28U W=2U AS=1P AD=1P PS=5U PD=5U
M$378 \$357 MO4 VSS VSS nfet_03v3 L=0.28U W=3U AS=1.5P AD=1.5P PS=7U PD=7U
M$379 \$640 \$890 VSS VSS nfet_03v3 L=0.28U W=2U AS=1P AD=1P PS=5U PD=5U
M$380 \$641 \$639 VSS VSS nfet_03v3 L=0.28U W=1U AS=0.5P AD=0.5P PS=3U PD=3U
M$381 \$642 CK4 VSS VSS nfet_03v3 L=0.28U W=1U AS=0.5P AD=0.5P PS=3U PD=3U
M$382 \$643 \$642 VSS VSS nfet_03v3 L=0.28U W=1U AS=0.5P AD=0.5P PS=3U PD=3U
M$383 \$644 \$642 \$641 VSS nfet_03v3 L=0.28U W=1U AS=0.5P AD=0.5P PS=3U PD=3U
M$384 \$645 \$644 VSS VSS nfet_03v3 L=0.28U W=1U AS=0.5P AD=0.5P PS=3U PD=3U
M$385 \$646 \$645 VSS VSS nfet_03v3 L=0.28U W=1U AS=0.5P AD=0.5P PS=3U PD=3U
M$386 \$644 \$643 \$646 VSS nfet_03v3 L=0.28U W=1U AS=0.5P AD=0.5P PS=3U PD=3U
M$387 \$647 \$643 \$645 VSS nfet_03v3 L=0.28U W=1U AS=0.5P AD=0.5P PS=3U PD=3U
M$388 \$648 \$647 VSS VSS nfet_03v3 L=0.28U W=1U AS=0.5P AD=0.5P PS=3U PD=3U
M$389 \$638 \$648 VSS VSS nfet_03v3 L=0.28U W=1U AS=0.5P AD=0.5P PS=3U PD=3U
M$390 \$647 \$642 \$638 VSS nfet_03v3 L=0.28U W=1U AS=0.5P AD=0.5P PS=3U PD=3U
M$391 CK5 \$638 VSS VSS nfet_03v3 L=0.28U W=2U AS=1P AD=1P PS=5U PD=5U
M$392 \$650 \$648 VSS VSS nfet_03v3 L=0.28U W=2U AS=1P AD=1P PS=5U PD=5U
M$393 \$652 \$651 VSS VSS nfet_03v3 L=0.28U W=1U AS=0.5P AD=0.5P PS=3U PD=3U
M$394 \$653 CK4 VSS VSS nfet_03v3 L=0.28U W=1U AS=0.5P AD=0.5P PS=3U PD=3U
M$395 \$654 \$653 VSS VSS nfet_03v3 L=0.28U W=1U AS=0.5P AD=0.5P PS=3U PD=3U
M$396 \$655 \$653 \$652 VSS nfet_03v3 L=0.28U W=1U AS=0.5P AD=0.5P PS=3U PD=3U
M$397 \$656 \$655 VSS VSS nfet_03v3 L=0.28U W=1U AS=0.5P AD=0.5P PS=3U PD=3U
M$398 \$657 \$656 VSS VSS nfet_03v3 L=0.28U W=1U AS=0.5P AD=0.5P PS=3U PD=3U
M$399 \$655 \$654 \$657 VSS nfet_03v3 L=0.28U W=1U AS=0.5P AD=0.5P PS=3U PD=3U
M$400 \$658 \$654 \$656 VSS nfet_03v3 L=0.28U W=1U AS=0.5P AD=0.5P PS=3U PD=3U
M$401 MO4 \$658 VSS VSS nfet_03v3 L=0.28U W=1U AS=0.5P AD=0.5P PS=3U PD=3U
M$402 \$659 MO4 VSS VSS nfet_03v3 L=0.28U W=1U AS=0.5P AD=0.5P PS=3U PD=3U
M$403 \$658 \$653 \$659 VSS nfet_03v3 L=0.28U W=1U AS=0.5P AD=0.5P PS=3U PD=3U
M$404 NMI4 MO5 VSS VSS nfet_03v3 L=0.28U W=1U AS=0.5P AD=0.5P PS=3U PD=3U
M$405 NMI4 SEL4 VSS VSS nfet_03v3 L=0.28U W=1U AS=0.5P AD=0.5P PS=3U PD=3U
M$406 MI4 NMI4 VSS VSS nfet_03v3 L=0.28U W=1U AS=0.5P AD=0.5P PS=3U PD=3U
M$407 XM4_NMID SEL4 VSS VSS nfet_03v3 L=0.28U W=2U AS=1P AD=1P PS=5U PD=5U
M$408 \$359 MO5 VSS VSS nfet_03v3 L=0.28U W=3U AS=1.5P AD=1.5P PS=7U PD=7U
M$409 \$665 \$892 VSS VSS nfet_03v3 L=0.28U W=2U AS=1P AD=1P PS=5U PD=5U
M$410 \$666 \$664 VSS VSS nfet_03v3 L=0.28U W=1U AS=0.5P AD=0.5P PS=3U PD=3U
M$411 \$667 CK5 VSS VSS nfet_03v3 L=0.28U W=1U AS=0.5P AD=0.5P PS=3U PD=3U
M$412 \$668 \$667 VSS VSS nfet_03v3 L=0.28U W=1U AS=0.5P AD=0.5P PS=3U PD=3U
M$413 \$669 \$667 \$666 VSS nfet_03v3 L=0.28U W=1U AS=0.5P AD=0.5P PS=3U PD=3U
M$414 \$670 \$669 VSS VSS nfet_03v3 L=0.28U W=1U AS=0.5P AD=0.5P PS=3U PD=3U
M$415 \$671 \$670 VSS VSS nfet_03v3 L=0.28U W=1U AS=0.5P AD=0.5P PS=3U PD=3U
M$416 \$669 \$668 \$671 VSS nfet_03v3 L=0.28U W=1U AS=0.5P AD=0.5P PS=3U PD=3U
M$417 \$672 \$668 \$670 VSS nfet_03v3 L=0.28U W=1U AS=0.5P AD=0.5P PS=3U PD=3U
M$418 \$673 \$672 VSS VSS nfet_03v3 L=0.28U W=1U AS=0.5P AD=0.5P PS=3U PD=3U
M$419 \$663 \$673 VSS VSS nfet_03v3 L=0.28U W=1U AS=0.5P AD=0.5P PS=3U PD=3U
M$420 \$672 \$667 \$663 VSS nfet_03v3 L=0.28U W=1U AS=0.5P AD=0.5P PS=3U PD=3U
M$421 CK6 \$663 VSS VSS nfet_03v3 L=0.28U W=2U AS=1P AD=1P PS=5U PD=5U
M$422 \$675 \$673 VSS VSS nfet_03v3 L=0.28U W=2U AS=1P AD=1P PS=5U PD=5U
M$423 \$676 \$674 VSS VSS nfet_03v3 L=0.28U W=1U AS=0.5P AD=0.5P PS=3U PD=3U
M$424 \$677 CK5 VSS VSS nfet_03v3 L=0.28U W=1U AS=0.5P AD=0.5P PS=3U PD=3U
M$425 \$678 \$677 VSS VSS nfet_03v3 L=0.28U W=1U AS=0.5P AD=0.5P PS=3U PD=3U
M$426 \$679 \$677 \$676 VSS nfet_03v3 L=0.28U W=1U AS=0.5P AD=0.5P PS=3U PD=3U
M$427 \$680 \$679 VSS VSS nfet_03v3 L=0.28U W=1U AS=0.5P AD=0.5P PS=3U PD=3U
M$428 \$681 \$680 VSS VSS nfet_03v3 L=0.28U W=1U AS=0.5P AD=0.5P PS=3U PD=3U
M$429 \$679 \$678 \$681 VSS nfet_03v3 L=0.28U W=1U AS=0.5P AD=0.5P PS=3U PD=3U
M$430 \$682 \$678 \$680 VSS nfet_03v3 L=0.28U W=1U AS=0.5P AD=0.5P PS=3U PD=3U
M$431 MO5 \$682 VSS VSS nfet_03v3 L=0.28U W=1U AS=0.5P AD=0.5P PS=3U PD=3U
M$432 \$683 MO5 VSS VSS nfet_03v3 L=0.28U W=1U AS=0.5P AD=0.5P PS=3U PD=3U
M$433 \$682 \$677 \$683 VSS nfet_03v3 L=0.28U W=1U AS=0.5P AD=0.5P PS=3U PD=3U
M$434 XM5_NMID SEL5 VSS VSS nfet_03v3 L=0.28U W=2U AS=1P AD=1P PS=5U PD=5U
M$435 XMB_NM2 T5 VSS VSS nfet_03v3 L=0.28U W=3U AS=1.5P AD=1.5P PS=7U PD=7U
M$436 \$612 P3 \$355 VSS nfet_03v3 L=0.28U W=3U AS=1.5P AD=1.5P PS=7U PD=7U
M$437 \$888 MI3 \$612 VSS nfet_03v3 L=0.28U W=3U AS=1.5P AD=1.5P PS=7U PD=7U
M$438 \$614 \$613 \$615 VSS nfet_03v3 L=0.28U W=2U AS=1P AD=1P PS=5U PD=5U
M$439 \$624 MI3 \$625 VSS nfet_03v3 L=0.28U W=2U AS=1P AD=1P PS=5U PD=5U
M$440 T3 CK4 XM3_NMID VSS nfet_03v3 L=0.28U W=2U AS=1P AD=1P PS=5U PD=5U
M$441 \$890 MI4 \$637 VSS nfet_03v3 L=0.28U W=3U AS=1.5P AD=1.5P PS=7U PD=7U
M$442 \$637 P4 \$357 VSS nfet_03v3 L=0.28U W=3U AS=1.5P AD=1.5P PS=7U PD=7U
M$443 \$639 \$638 \$640 VSS nfet_03v3 L=0.28U W=2U AS=1P AD=1P PS=5U PD=5U
M$444 \$651 MI4 \$650 VSS nfet_03v3 L=0.28U W=2U AS=1P AD=1P PS=5U PD=5U
M$445 T4 CK5 XM4_NMID VSS nfet_03v3 L=0.28U W=2U AS=1P AD=1P PS=5U PD=5U
M$446 \$892 SEL5 \$662 VSS nfet_03v3 L=0.28U W=3U AS=1.5P AD=1.5P PS=7U PD=7U
M$447 \$662 P5 \$359 VSS nfet_03v3 L=0.28U W=3U AS=1.5P AD=1.5P PS=7U PD=7U
M$448 \$664 \$663 \$665 VSS nfet_03v3 L=0.28U W=2U AS=1P AD=1P PS=5U PD=5U
M$449 \$674 SEL5 \$675 VSS nfet_03v3 L=0.28U W=2U AS=1P AD=1P PS=5U PD=5U
M$450 T5 CK6 XM5_NMID VSS nfet_03v3 L=0.28U W=2U AS=1P AD=1P PS=5U PD=5U
M$451 MB T3 XMB_NM1 VSS nfet_03v3 L=0.28U W=3U AS=1.5P AD=1.5P PS=7U PD=7U
M$452 XMB_NM1 T4 XMB_NM2 VSS nfet_03v3 L=0.28U W=3U AS=1.5P AD=1.5P PS=7U PD=7U
.ENDS divider_chain
