* Extracted by KLayout with GF180MCU LVS runset on : 09/09/2026 06:35

.SUBCKT divider_chain VSS MA MO0|MODOUT CKIN|VCO MO1|MODOUT MO2|MODOUT DIVOUTB
+ DIVOUT MI0|MODIN P|P0 VDD|VDD_DIV CK1|CKIN|CKOUT NMI0 T0 XM0_NMID MI1|MODIN
+ P|P1 CK2|CKIN|CKOUT NMI1 XM1_NMID T1 MI2|MODIN P|P2 CK3|CKIN|CKOUT NMI2 T2
+ XM2_NMID XMA_NM2 XMA_NM1 MB SEL0 SEL1 SEL2 XMNO_PMID XNR0_PMID XNR1_PMID
+ XNR2_PMID MO3|MODOUT MO4|MODOUT MO5|MODOUT XFRT_CKB XFRT_CKBB XFRT_NM
+ XFRT_NMA XFRT_NMB XFRT_NS FB FBB CK4|CKIN|CKOUT NMI3 XM3_NMID CK5|CKIN|CKOUT
+ NMI4 XM4_NMID CK6|CKOUT XM5_NMID XMB_NM2 MI3|MODIN P|P3 T3 MI4|MODIN P|P4 T4
+ MODIN|SEL5 P|P5 T5 XMB_NM1 SEL3 SEL4 XNR3_PMID XNR4_PMID
M$1 XMNO_PMID MB DIVOUTB VDD|VDD_DIV pfet_03v3 L=0.28U W=5U AS=2.5P AD=2.5P
+ PS=11U PD=11U
M$2 VDD|VDD_DIV DIVOUTB DIVOUT VDD|VDD_DIV pfet_03v3 L=0.28U W=5U AS=2.5P
+ AD=2.5P PS=11U PD=11U
M$3 VDD|VDD_DIV MI0|MODIN \$13 VDD|VDD_DIV pfet_03v3 L=0.28U W=2.5U AS=1.25P
+ AD=1.25P PS=6U PD=6U
M$4 VDD|VDD_DIV P|P0 \$13 VDD|VDD_DIV pfet_03v3 L=0.28U W=2.5U AS=1.25P
+ AD=1.25P PS=6U PD=6U
M$5 VDD|VDD_DIV MO0|MODOUT \$13 VDD|VDD_DIV pfet_03v3 L=0.28U W=2.5U AS=1.25P
+ AD=1.25P PS=6U PD=6U
M$6 VDD|VDD_DIV \$15 \$17 VDD|VDD_DIV pfet_03v3 L=0.28U W=2.5U AS=1.25P
+ AD=1.25P PS=6U PD=6U
M$7 VDD|VDD_DIV \$13 \$17 VDD|VDD_DIV pfet_03v3 L=0.28U W=2.5U AS=1.25P
+ AD=1.25P PS=6U PD=6U
M$8 VDD|VDD_DIV \$17 \$18 VDD|VDD_DIV pfet_03v3 L=0.28U W=2.5U AS=1.25P
+ AD=1.25P PS=6U PD=6U
M$9 VDD|VDD_DIV CKIN|VCO \$19 VDD|VDD_DIV pfet_03v3 L=0.28U W=2.5U AS=1.25P
+ AD=1.25P PS=6U PD=6U
M$10 VDD|VDD_DIV \$19 \$20 VDD|VDD_DIV pfet_03v3 L=0.28U W=2.5U AS=1.25P
+ AD=1.25P PS=6U PD=6U
M$11 \$18 \$20 \$21 VDD|VDD_DIV pfet_03v3 L=0.28U W=2.5U AS=1.25P AD=1.25P
+ PS=6U PD=6U
M$12 VDD|VDD_DIV \$21 \$22 VDD|VDD_DIV pfet_03v3 L=0.28U W=2.5U AS=1.25P
+ AD=1.25P PS=6U PD=6U
M$13 VDD|VDD_DIV \$22 \$23 VDD|VDD_DIV pfet_03v3 L=0.28U W=2.5U AS=1.25P
+ AD=1.25P PS=6U PD=6U
M$14 \$23 \$19 \$21 VDD|VDD_DIV pfet_03v3 L=0.28U W=2.5U AS=1.25P AD=1.25P
+ PS=6U PD=6U
M$15 \$22 \$19 \$24 VDD|VDD_DIV pfet_03v3 L=0.28U W=2.5U AS=1.25P AD=1.25P
+ PS=6U PD=6U
M$16 VDD|VDD_DIV \$24 \$25 VDD|VDD_DIV pfet_03v3 L=0.28U W=2.5U AS=1.25P
+ AD=1.25P PS=6U PD=6U
M$17 VDD|VDD_DIV \$25 \$15 VDD|VDD_DIV pfet_03v3 L=0.28U W=2.5U AS=1.25P
+ AD=1.25P PS=6U PD=6U
M$18 \$15 \$20 \$24 VDD|VDD_DIV pfet_03v3 L=0.28U W=2.5U AS=1.25P AD=1.25P
+ PS=6U PD=6U
M$19 VDD|VDD_DIV \$15 CK1|CKIN|CKOUT VDD|VDD_DIV pfet_03v3 L=0.28U W=5U AS=2.5P
+ AD=2.5P PS=11U PD=11U
M$20 VDD|VDD_DIV MI0|MODIN \$28 VDD|VDD_DIV pfet_03v3 L=0.28U W=2.5U AS=1.25P
+ AD=1.25P PS=6U PD=6U
M$21 VDD|VDD_DIV \$25 \$28 VDD|VDD_DIV pfet_03v3 L=0.28U W=2.5U AS=1.25P
+ AD=1.25P PS=6U PD=6U
M$22 VDD|VDD_DIV \$28 \$29 VDD|VDD_DIV pfet_03v3 L=0.28U W=2.5U AS=1.25P
+ AD=1.25P PS=6U PD=6U
M$23 VDD|VDD_DIV CKIN|VCO \$30 VDD|VDD_DIV pfet_03v3 L=0.28U W=2.5U AS=1.25P
+ AD=1.25P PS=6U PD=6U
M$24 VDD|VDD_DIV \$30 \$31 VDD|VDD_DIV pfet_03v3 L=0.28U W=2.5U AS=1.25P
+ AD=1.25P PS=6U PD=6U
M$25 \$29 \$31 \$32 VDD|VDD_DIV pfet_03v3 L=0.28U W=2.5U AS=1.25P AD=1.25P
+ PS=6U PD=6U
M$26 VDD|VDD_DIV \$32 \$33 VDD|VDD_DIV pfet_03v3 L=0.28U W=2.5U AS=1.25P
+ AD=1.25P PS=6U PD=6U
M$27 VDD|VDD_DIV \$33 \$34 VDD|VDD_DIV pfet_03v3 L=0.28U W=2.5U AS=1.25P
+ AD=1.25P PS=6U PD=6U
M$28 \$34 \$30 \$32 VDD|VDD_DIV pfet_03v3 L=0.28U W=2.5U AS=1.25P AD=1.25P
+ PS=6U PD=6U
M$29 \$33 \$30 \$35 VDD|VDD_DIV pfet_03v3 L=0.28U W=2.5U AS=1.25P AD=1.25P
+ PS=6U PD=6U
M$30 VDD|VDD_DIV \$35 MO0|MODOUT VDD|VDD_DIV pfet_03v3 L=0.28U W=2.5U AS=1.25P
+ AD=1.25P PS=6U PD=6U
M$31 VDD|VDD_DIV MO0|MODOUT \$36 VDD|VDD_DIV pfet_03v3 L=0.28U W=2.5U AS=1.25P
+ AD=1.25P PS=6U PD=6U
M$32 \$36 \$31 \$35 VDD|VDD_DIV pfet_03v3 L=0.28U W=2.5U AS=1.25P AD=1.25P
+ PS=6U PD=6U
M$33 XNR0_PMID SEL0 NMI0 VDD|VDD_DIV pfet_03v3 L=0.28U W=5U AS=2.5P AD=2.5P
+ PS=11U PD=11U
M$34 VDD|VDD_DIV NMI0 MI0|MODIN VDD|VDD_DIV pfet_03v3 L=0.28U W=2.5U AS=1.25P
+ AD=1.25P PS=6U PD=6U
M$35 VDD|VDD_DIV CK1|CKIN|CKOUT T0 VDD|VDD_DIV pfet_03v3 L=0.28U W=2.5U
+ AS=1.25P AD=1.25P PS=6U PD=6U
M$36 VDD|VDD_DIV SEL0 T0 VDD|VDD_DIV pfet_03v3 L=0.28U W=2.5U AS=1.25P AD=1.25P
+ PS=6U PD=6U
M$37 VDD|VDD_DIV MI1|MODIN \$43 VDD|VDD_DIV pfet_03v3 L=0.28U W=2.5U AS=1.25P
+ AD=1.25P PS=6U PD=6U
M$38 VDD|VDD_DIV P|P1 \$43 VDD|VDD_DIV pfet_03v3 L=0.28U W=2.5U AS=1.25P
+ AD=1.25P PS=6U PD=6U
M$39 VDD|VDD_DIV MO1|MODOUT \$43 VDD|VDD_DIV pfet_03v3 L=0.28U W=2.5U AS=1.25P
+ AD=1.25P PS=6U PD=6U
M$40 VDD|VDD_DIV \$45 \$46 VDD|VDD_DIV pfet_03v3 L=0.28U W=2.5U AS=1.25P
+ AD=1.25P PS=6U PD=6U
M$41 VDD|VDD_DIV \$43 \$46 VDD|VDD_DIV pfet_03v3 L=0.28U W=2.5U AS=1.25P
+ AD=1.25P PS=6U PD=6U
M$42 VDD|VDD_DIV \$46 \$48 VDD|VDD_DIV pfet_03v3 L=0.28U W=2.5U AS=1.25P
+ AD=1.25P PS=6U PD=6U
M$43 VDD|VDD_DIV CK1|CKIN|CKOUT \$49 VDD|VDD_DIV pfet_03v3 L=0.28U W=2.5U
+ AS=1.25P AD=1.25P PS=6U PD=6U
M$44 VDD|VDD_DIV \$49 \$50 VDD|VDD_DIV pfet_03v3 L=0.28U W=2.5U AS=1.25P
+ AD=1.25P PS=6U PD=6U
M$45 \$48 \$50 \$51 VDD|VDD_DIV pfet_03v3 L=0.28U W=2.5U AS=1.25P AD=1.25P
+ PS=6U PD=6U
M$46 VDD|VDD_DIV \$51 \$52 VDD|VDD_DIV pfet_03v3 L=0.28U W=2.5U AS=1.25P
+ AD=1.25P PS=6U PD=6U
M$47 VDD|VDD_DIV \$52 \$53 VDD|VDD_DIV pfet_03v3 L=0.28U W=2.5U AS=1.25P
+ AD=1.25P PS=6U PD=6U
M$48 \$53 \$49 \$51 VDD|VDD_DIV pfet_03v3 L=0.28U W=2.5U AS=1.25P AD=1.25P
+ PS=6U PD=6U
M$49 \$52 \$49 \$54 VDD|VDD_DIV pfet_03v3 L=0.28U W=2.5U AS=1.25P AD=1.25P
+ PS=6U PD=6U
M$50 VDD|VDD_DIV \$54 \$55 VDD|VDD_DIV pfet_03v3 L=0.28U W=2.5U AS=1.25P
+ AD=1.25P PS=6U PD=6U
M$51 VDD|VDD_DIV \$55 \$45 VDD|VDD_DIV pfet_03v3 L=0.28U W=2.5U AS=1.25P
+ AD=1.25P PS=6U PD=6U
M$52 \$45 \$50 \$54 VDD|VDD_DIV pfet_03v3 L=0.28U W=2.5U AS=1.25P AD=1.25P
+ PS=6U PD=6U
M$53 VDD|VDD_DIV \$45 CK2|CKIN|CKOUT VDD|VDD_DIV pfet_03v3 L=0.28U W=5U AS=2.5P
+ AD=2.5P PS=11U PD=11U
M$54 VDD|VDD_DIV MI1|MODIN \$57 VDD|VDD_DIV pfet_03v3 L=0.28U W=2.5U AS=1.25P
+ AD=1.25P PS=6U PD=6U
M$55 VDD|VDD_DIV \$55 \$57 VDD|VDD_DIV pfet_03v3 L=0.28U W=2.5U AS=1.25P
+ AD=1.25P PS=6U PD=6U
M$56 VDD|VDD_DIV \$57 \$59 VDD|VDD_DIV pfet_03v3 L=0.28U W=2.5U AS=1.25P
+ AD=1.25P PS=6U PD=6U
M$57 VDD|VDD_DIV CK1|CKIN|CKOUT \$60 VDD|VDD_DIV pfet_03v3 L=0.28U W=2.5U
+ AS=1.25P AD=1.25P PS=6U PD=6U
M$58 VDD|VDD_DIV \$60 \$61 VDD|VDD_DIV pfet_03v3 L=0.28U W=2.5U AS=1.25P
+ AD=1.25P PS=6U PD=6U
M$59 \$59 \$61 \$62 VDD|VDD_DIV pfet_03v3 L=0.28U W=2.5U AS=1.25P AD=1.25P
+ PS=6U PD=6U
M$60 VDD|VDD_DIV \$62 \$63 VDD|VDD_DIV pfet_03v3 L=0.28U W=2.5U AS=1.25P
+ AD=1.25P PS=6U PD=6U
M$61 VDD|VDD_DIV \$63 \$64 VDD|VDD_DIV pfet_03v3 L=0.28U W=2.5U AS=1.25P
+ AD=1.25P PS=6U PD=6U
M$62 \$64 \$60 \$62 VDD|VDD_DIV pfet_03v3 L=0.28U W=2.5U AS=1.25P AD=1.25P
+ PS=6U PD=6U
M$63 \$63 \$60 \$65 VDD|VDD_DIV pfet_03v3 L=0.28U W=2.5U AS=1.25P AD=1.25P
+ PS=6U PD=6U
M$64 VDD|VDD_DIV \$65 MO1|MODOUT VDD|VDD_DIV pfet_03v3 L=0.28U W=2.5U AS=1.25P
+ AD=1.25P PS=6U PD=6U
M$65 VDD|VDD_DIV MO1|MODOUT \$66 VDD|VDD_DIV pfet_03v3 L=0.28U W=2.5U AS=1.25P
+ AD=1.25P PS=6U PD=6U
M$66 \$66 \$61 \$65 VDD|VDD_DIV pfet_03v3 L=0.28U W=2.5U AS=1.25P AD=1.25P
+ PS=6U PD=6U
M$67 XNR1_PMID SEL1 NMI1 VDD|VDD_DIV pfet_03v3 L=0.28U W=5U AS=2.5P AD=2.5P
+ PS=11U PD=11U
M$68 VDD|VDD_DIV NMI1 MI1|MODIN VDD|VDD_DIV pfet_03v3 L=0.28U W=2.5U AS=1.25P
+ AD=1.25P PS=6U PD=6U
M$69 VDD|VDD_DIV CK2|CKIN|CKOUT T1 VDD|VDD_DIV pfet_03v3 L=0.28U W=2.5U
+ AS=1.25P AD=1.25P PS=6U PD=6U
M$70 VDD|VDD_DIV SEL1 T1 VDD|VDD_DIV pfet_03v3 L=0.28U W=2.5U AS=1.25P AD=1.25P
+ PS=6U PD=6U
M$71 VDD|VDD_DIV MI2|MODIN \$74 VDD|VDD_DIV pfet_03v3 L=0.28U W=2.5U AS=1.25P
+ AD=1.25P PS=6U PD=6U
M$72 VDD|VDD_DIV P|P2 \$74 VDD|VDD_DIV pfet_03v3 L=0.28U W=2.5U AS=1.25P
+ AD=1.25P PS=6U PD=6U
M$73 VDD|VDD_DIV MO2|MODOUT \$74 VDD|VDD_DIV pfet_03v3 L=0.28U W=2.5U AS=1.25P
+ AD=1.25P PS=6U PD=6U
M$74 VDD|VDD_DIV \$75 \$76 VDD|VDD_DIV pfet_03v3 L=0.28U W=2.5U AS=1.25P
+ AD=1.25P PS=6U PD=6U
M$75 VDD|VDD_DIV \$74 \$76 VDD|VDD_DIV pfet_03v3 L=0.28U W=2.5U AS=1.25P
+ AD=1.25P PS=6U PD=6U
M$76 VDD|VDD_DIV \$76 \$78 VDD|VDD_DIV pfet_03v3 L=0.28U W=2.5U AS=1.25P
+ AD=1.25P PS=6U PD=6U
M$77 VDD|VDD_DIV CK2|CKIN|CKOUT \$79 VDD|VDD_DIV pfet_03v3 L=0.28U W=2.5U
+ AS=1.25P AD=1.25P PS=6U PD=6U
M$78 VDD|VDD_DIV \$79 \$80 VDD|VDD_DIV pfet_03v3 L=0.28U W=2.5U AS=1.25P
+ AD=1.25P PS=6U PD=6U
M$79 \$78 \$80 \$81 VDD|VDD_DIV pfet_03v3 L=0.28U W=2.5U AS=1.25P AD=1.25P
+ PS=6U PD=6U
M$80 VDD|VDD_DIV \$81 \$82 VDD|VDD_DIV pfet_03v3 L=0.28U W=2.5U AS=1.25P
+ AD=1.25P PS=6U PD=6U
M$81 VDD|VDD_DIV \$82 \$83 VDD|VDD_DIV pfet_03v3 L=0.28U W=2.5U AS=1.25P
+ AD=1.25P PS=6U PD=6U
M$82 \$83 \$79 \$81 VDD|VDD_DIV pfet_03v3 L=0.28U W=2.5U AS=1.25P AD=1.25P
+ PS=6U PD=6U
M$83 \$82 \$79 \$84 VDD|VDD_DIV pfet_03v3 L=0.28U W=2.5U AS=1.25P AD=1.25P
+ PS=6U PD=6U
M$84 VDD|VDD_DIV \$84 \$85 VDD|VDD_DIV pfet_03v3 L=0.28U W=2.5U AS=1.25P
+ AD=1.25P PS=6U PD=6U
M$85 VDD|VDD_DIV \$85 \$75 VDD|VDD_DIV pfet_03v3 L=0.28U W=2.5U AS=1.25P
+ AD=1.25P PS=6U PD=6U
M$86 \$75 \$80 \$84 VDD|VDD_DIV pfet_03v3 L=0.28U W=2.5U AS=1.25P AD=1.25P
+ PS=6U PD=6U
M$87 VDD|VDD_DIV \$75 CK3|CKIN|CKOUT VDD|VDD_DIV pfet_03v3 L=0.28U W=5U AS=2.5P
+ AD=2.5P PS=11U PD=11U
M$88 VDD|VDD_DIV MI2|MODIN \$88 VDD|VDD_DIV pfet_03v3 L=0.28U W=2.5U AS=1.25P
+ AD=1.25P PS=6U PD=6U
M$89 VDD|VDD_DIV \$85 \$88 VDD|VDD_DIV pfet_03v3 L=0.28U W=2.5U AS=1.25P
+ AD=1.25P PS=6U PD=6U
M$90 VDD|VDD_DIV \$88 \$89 VDD|VDD_DIV pfet_03v3 L=0.28U W=2.5U AS=1.25P
+ AD=1.25P PS=6U PD=6U
M$91 VDD|VDD_DIV CK2|CKIN|CKOUT \$90 VDD|VDD_DIV pfet_03v3 L=0.28U W=2.5U
+ AS=1.25P AD=1.25P PS=6U PD=6U
M$92 VDD|VDD_DIV \$90 \$91 VDD|VDD_DIV pfet_03v3 L=0.28U W=2.5U AS=1.25P
+ AD=1.25P PS=6U PD=6U
M$93 \$89 \$91 \$92 VDD|VDD_DIV pfet_03v3 L=0.28U W=2.5U AS=1.25P AD=1.25P
+ PS=6U PD=6U
M$94 VDD|VDD_DIV \$92 \$93 VDD|VDD_DIV pfet_03v3 L=0.28U W=2.5U AS=1.25P
+ AD=1.25P PS=6U PD=6U
M$95 VDD|VDD_DIV \$93 \$94 VDD|VDD_DIV pfet_03v3 L=0.28U W=2.5U AS=1.25P
+ AD=1.25P PS=6U PD=6U
M$96 \$94 \$90 \$92 VDD|VDD_DIV pfet_03v3 L=0.28U W=2.5U AS=1.25P AD=1.25P
+ PS=6U PD=6U
M$97 \$93 \$90 \$95 VDD|VDD_DIV pfet_03v3 L=0.28U W=2.5U AS=1.25P AD=1.25P
+ PS=6U PD=6U
M$98 VDD|VDD_DIV \$95 MO2|MODOUT VDD|VDD_DIV pfet_03v3 L=0.28U W=2.5U AS=1.25P
+ AD=1.25P PS=6U PD=6U
M$99 VDD|VDD_DIV MO2|MODOUT \$96 VDD|VDD_DIV pfet_03v3 L=0.28U W=2.5U AS=1.25P
+ AD=1.25P PS=6U PD=6U
M$100 \$96 \$91 \$95 VDD|VDD_DIV pfet_03v3 L=0.28U W=2.5U AS=1.25P AD=1.25P
+ PS=6U PD=6U
M$101 XNR2_PMID SEL2 NMI2 VDD|VDD_DIV pfet_03v3 L=0.28U W=5U AS=2.5P AD=2.5P
+ PS=11U PD=11U
M$102 VDD|VDD_DIV NMI2 MI2|MODIN VDD|VDD_DIV pfet_03v3 L=0.28U W=2.5U AS=1.25P
+ AD=1.25P PS=6U PD=6U
M$103 VDD|VDD_DIV CK3|CKIN|CKOUT T2 VDD|VDD_DIV pfet_03v3 L=0.28U W=2.5U
+ AS=1.25P AD=1.25P PS=6U PD=6U
M$104 VDD|VDD_DIV SEL2 T2 VDD|VDD_DIV pfet_03v3 L=0.28U W=2.5U AS=1.25P
+ AD=1.25P PS=6U PD=6U
M$105 VDD|VDD_DIV T0 MA VDD|VDD_DIV pfet_03v3 L=0.28U W=2.5U AS=1.25P AD=1.25P
+ PS=6U PD=6U
M$106 VDD|VDD_DIV T1 MA VDD|VDD_DIV pfet_03v3 L=0.28U W=2.5U AS=1.25P AD=1.25P
+ PS=6U PD=6U
M$107 VDD|VDD_DIV T2 MA VDD|VDD_DIV pfet_03v3 L=0.28U W=2.5U AS=1.25P AD=1.25P
+ PS=6U PD=6U
M$108 VDD|VDD_DIV MA XMNO_PMID VDD|VDD_DIV pfet_03v3 L=0.28U W=5U AS=2.5P
+ AD=2.5P PS=11U PD=11U
M$109 VDD|VDD_DIV MO1|MODOUT XNR0_PMID VDD|VDD_DIV pfet_03v3 L=0.28U W=5U
+ AS=2.5P AD=2.5P PS=11U PD=11U
M$110 VDD|VDD_DIV MO2|MODOUT XNR1_PMID VDD|VDD_DIV pfet_03v3 L=0.28U W=5U
+ AS=2.5P AD=2.5P PS=11U PD=11U
M$111 VDD|VDD_DIV MO3|MODOUT XNR2_PMID VDD|VDD_DIV pfet_03v3 L=0.28U W=5U
+ AS=2.5P AD=2.5P PS=11U PD=11U
M$112 VDD|VDD_DIV CKIN|VCO XFRT_CKB VDD|VDD_DIV pfet_03v3 L=0.28U W=2.5U
+ AS=1.25P AD=1.25P PS=6U PD=6U
M$113 VDD|VDD_DIV XFRT_CKB XFRT_CKBB VDD|VDD_DIV pfet_03v3 L=0.28U W=2.5U
+ AS=1.25P AD=1.25P PS=6U PD=6U
M$114 DIVOUT XFRT_CKBB XFRT_NM VDD|VDD_DIV pfet_03v3 L=0.28U W=2.5U AS=1.25P
+ AD=1.25P PS=6U PD=6U
M$115 VDD|VDD_DIV XFRT_NM XFRT_NMA VDD|VDD_DIV pfet_03v3 L=0.28U W=2.5U
+ AS=1.25P AD=1.25P PS=6U PD=6U
M$116 VDD|VDD_DIV XFRT_NMA XFRT_NMB VDD|VDD_DIV pfet_03v3 L=0.28U W=2.5U
+ AS=1.25P AD=1.25P PS=6U PD=6U
M$117 XFRT_NMB XFRT_CKB XFRT_NM VDD|VDD_DIV pfet_03v3 L=0.28U W=2.5U AS=1.25P
+ AD=1.25P PS=6U PD=6U
M$118 XFRT_NMA XFRT_CKB XFRT_NS VDD|VDD_DIV pfet_03v3 L=0.28U W=2.5U AS=1.25P
+ AD=1.25P PS=6U PD=6U
M$119 VDD|VDD_DIV XFRT_NS FB VDD|VDD_DIV pfet_03v3 L=0.28U W=2.5U AS=1.25P
+ AD=1.25P PS=6U PD=6U
M$120 VDD|VDD_DIV FB FBB VDD|VDD_DIV pfet_03v3 L=0.28U W=2.5U AS=1.25P AD=1.25P
+ PS=6U PD=6U
M$121 FBB XFRT_CKBB XFRT_NS VDD|VDD_DIV pfet_03v3 L=0.28U W=2.5U AS=1.25P
+ AD=1.25P PS=6U PD=6U
M$122 VDD|VDD_DIV MI3|MODIN \$879 VDD|VDD_DIV pfet_03v3 L=0.28U W=2.5U AS=1.25P
+ AD=1.25P PS=6U PD=6U
M$123 VDD|VDD_DIV P|P3 \$879 VDD|VDD_DIV pfet_03v3 L=0.28U W=2.5U AS=1.25P
+ AD=1.25P PS=6U PD=6U
M$124 VDD|VDD_DIV MO3|MODOUT \$879 VDD|VDD_DIV pfet_03v3 L=0.28U W=2.5U
+ AS=1.25P AD=1.25P PS=6U PD=6U
M$125 VDD|VDD_DIV \$847 \$848 VDD|VDD_DIV pfet_03v3 L=0.28U W=2.5U AS=1.25P
+ AD=1.25P PS=6U PD=6U
M$126 VDD|VDD_DIV \$879 \$848 VDD|VDD_DIV pfet_03v3 L=0.28U W=2.5U AS=1.25P
+ AD=1.25P PS=6U PD=6U
M$127 VDD|VDD_DIV \$848 \$574 VDD|VDD_DIV pfet_03v3 L=0.28U W=2.5U AS=1.25P
+ AD=1.25P PS=6U PD=6U
M$128 VDD|VDD_DIV CK3|CKIN|CKOUT \$575 VDD|VDD_DIV pfet_03v3 L=0.28U W=2.5U
+ AS=1.25P AD=1.25P PS=6U PD=6U
M$129 VDD|VDD_DIV \$575 \$576 VDD|VDD_DIV pfet_03v3 L=0.28U W=2.5U AS=1.25P
+ AD=1.25P PS=6U PD=6U
M$130 \$574 \$576 \$886 VDD|VDD_DIV pfet_03v3 L=0.28U W=2.5U AS=1.25P AD=1.25P
+ PS=6U PD=6U
M$131 VDD|VDD_DIV \$886 \$577 VDD|VDD_DIV pfet_03v3 L=0.28U W=2.5U AS=1.25P
+ AD=1.25P PS=6U PD=6U
M$132 VDD|VDD_DIV \$577 \$578 VDD|VDD_DIV pfet_03v3 L=0.28U W=2.5U AS=1.25P
+ AD=1.25P PS=6U PD=6U
M$133 \$578 \$575 \$886 VDD|VDD_DIV pfet_03v3 L=0.28U W=2.5U AS=1.25P AD=1.25P
+ PS=6U PD=6U
M$134 \$577 \$575 \$579 VDD|VDD_DIV pfet_03v3 L=0.28U W=2.5U AS=1.25P AD=1.25P
+ PS=6U PD=6U
M$135 VDD|VDD_DIV \$579 \$580 VDD|VDD_DIV pfet_03v3 L=0.28U W=2.5U AS=1.25P
+ AD=1.25P PS=6U PD=6U
M$136 VDD|VDD_DIV \$580 \$847 VDD|VDD_DIV pfet_03v3 L=0.28U W=2.5U AS=1.25P
+ AD=1.25P PS=6U PD=6U
M$137 \$847 \$576 \$579 VDD|VDD_DIV pfet_03v3 L=0.28U W=2.5U AS=1.25P AD=1.25P
+ PS=6U PD=6U
M$138 VDD|VDD_DIV \$847 CK4|CKIN|CKOUT VDD|VDD_DIV pfet_03v3 L=0.28U W=5U
+ AS=2.5P AD=2.5P PS=11U PD=11U
M$139 VDD|VDD_DIV MI3|MODIN \$849 VDD|VDD_DIV pfet_03v3 L=0.28U W=2.5U AS=1.25P
+ AD=1.25P PS=6U PD=6U
M$140 VDD|VDD_DIV \$580 \$849 VDD|VDD_DIV pfet_03v3 L=0.28U W=2.5U AS=1.25P
+ AD=1.25P PS=6U PD=6U
M$141 VDD|VDD_DIV \$849 \$583 VDD|VDD_DIV pfet_03v3 L=0.28U W=2.5U AS=1.25P
+ AD=1.25P PS=6U PD=6U
M$142 VDD|VDD_DIV CK3|CKIN|CKOUT \$584 VDD|VDD_DIV pfet_03v3 L=0.28U W=2.5U
+ AS=1.25P AD=1.25P PS=6U PD=6U
M$143 VDD|VDD_DIV \$584 \$585 VDD|VDD_DIV pfet_03v3 L=0.28U W=2.5U AS=1.25P
+ AD=1.25P PS=6U PD=6U
M$144 \$583 \$585 \$887 VDD|VDD_DIV pfet_03v3 L=0.28U W=2.5U AS=1.25P AD=1.25P
+ PS=6U PD=6U
M$145 VDD|VDD_DIV \$887 \$586 VDD|VDD_DIV pfet_03v3 L=0.28U W=2.5U AS=1.25P
+ AD=1.25P PS=6U PD=6U
M$146 VDD|VDD_DIV \$586 \$888 VDD|VDD_DIV pfet_03v3 L=0.28U W=2.5U AS=1.25P
+ AD=1.25P PS=6U PD=6U
M$147 \$888 \$584 \$887 VDD|VDD_DIV pfet_03v3 L=0.28U W=2.5U AS=1.25P AD=1.25P
+ PS=6U PD=6U
M$148 \$586 \$584 \$587 VDD|VDD_DIV pfet_03v3 L=0.28U W=2.5U AS=1.25P AD=1.25P
+ PS=6U PD=6U
M$149 VDD|VDD_DIV \$587 MO3|MODOUT VDD|VDD_DIV pfet_03v3 L=0.28U W=2.5U
+ AS=1.25P AD=1.25P PS=6U PD=6U
M$150 VDD|VDD_DIV MO3|MODOUT \$588 VDD|VDD_DIV pfet_03v3 L=0.28U W=2.5U
+ AS=1.25P AD=1.25P PS=6U PD=6U
M$151 \$588 \$585 \$587 VDD|VDD_DIV pfet_03v3 L=0.28U W=2.5U AS=1.25P AD=1.25P
+ PS=6U PD=6U
M$152 XNR3_PMID SEL3 NMI3 VDD|VDD_DIV pfet_03v3 L=0.28U W=5U AS=2.5P AD=2.5P
+ PS=11U PD=11U
M$153 VDD|VDD_DIV NMI3 MI3|MODIN VDD|VDD_DIV pfet_03v3 L=0.28U W=2.5U AS=1.25P
+ AD=1.25P PS=6U PD=6U
M$154 VDD|VDD_DIV CK4|CKIN|CKOUT T3 VDD|VDD_DIV pfet_03v3 L=0.28U W=2.5U
+ AS=1.25P AD=1.25P PS=6U PD=6U
M$155 VDD|VDD_DIV SEL3 T3 VDD|VDD_DIV pfet_03v3 L=0.28U W=2.5U AS=1.25P
+ AD=1.25P PS=6U PD=6U
M$156 VDD|VDD_DIV MI4|MODIN \$880 VDD|VDD_DIV pfet_03v3 L=0.28U W=2.5U AS=1.25P
+ AD=1.25P PS=6U PD=6U
M$157 VDD|VDD_DIV P|P4 \$880 VDD|VDD_DIV pfet_03v3 L=0.28U W=2.5U AS=1.25P
+ AD=1.25P PS=6U PD=6U
M$158 VDD|VDD_DIV MO4|MODOUT \$880 VDD|VDD_DIV pfet_03v3 L=0.28U W=2.5U
+ AS=1.25P AD=1.25P PS=6U PD=6U
M$159 VDD|VDD_DIV \$854 \$855 VDD|VDD_DIV pfet_03v3 L=0.28U W=2.5U AS=1.25P
+ AD=1.25P PS=6U PD=6U
M$160 VDD|VDD_DIV \$880 \$855 VDD|VDD_DIV pfet_03v3 L=0.28U W=2.5U AS=1.25P
+ AD=1.25P PS=6U PD=6U
M$161 VDD|VDD_DIV \$855 \$593 VDD|VDD_DIV pfet_03v3 L=0.28U W=2.5U AS=1.25P
+ AD=1.25P PS=6U PD=6U
M$162 VDD|VDD_DIV CK4|CKIN|CKOUT \$594 VDD|VDD_DIV pfet_03v3 L=0.28U W=2.5U
+ AS=1.25P AD=1.25P PS=6U PD=6U
M$163 VDD|VDD_DIV \$594 \$890 VDD|VDD_DIV pfet_03v3 L=0.28U W=2.5U AS=1.25P
+ AD=1.25P PS=6U PD=6U
M$164 \$593 \$890 \$595 VDD|VDD_DIV pfet_03v3 L=0.28U W=2.5U AS=1.25P AD=1.25P
+ PS=6U PD=6U
M$165 VDD|VDD_DIV \$595 \$596 VDD|VDD_DIV pfet_03v3 L=0.28U W=2.5U AS=1.25P
+ AD=1.25P PS=6U PD=6U
M$166 VDD|VDD_DIV \$596 \$597 VDD|VDD_DIV pfet_03v3 L=0.28U W=2.5U AS=1.25P
+ AD=1.25P PS=6U PD=6U
M$167 \$597 \$594 \$595 VDD|VDD_DIV pfet_03v3 L=0.28U W=2.5U AS=1.25P AD=1.25P
+ PS=6U PD=6U
M$168 \$596 \$594 \$598 VDD|VDD_DIV pfet_03v3 L=0.28U W=2.5U AS=1.25P AD=1.25P
+ PS=6U PD=6U
M$169 VDD|VDD_DIV \$598 \$599 VDD|VDD_DIV pfet_03v3 L=0.28U W=2.5U AS=1.25P
+ AD=1.25P PS=6U PD=6U
M$170 VDD|VDD_DIV \$599 \$854 VDD|VDD_DIV pfet_03v3 L=0.28U W=2.5U AS=1.25P
+ AD=1.25P PS=6U PD=6U
M$171 \$854 \$890 \$598 VDD|VDD_DIV pfet_03v3 L=0.28U W=2.5U AS=1.25P AD=1.25P
+ PS=6U PD=6U
M$172 VDD|VDD_DIV \$854 CK5|CKIN|CKOUT VDD|VDD_DIV pfet_03v3 L=0.28U W=5U
+ AS=2.5P AD=2.5P PS=11U PD=11U
M$173 VDD|VDD_DIV MI4|MODIN \$856 VDD|VDD_DIV pfet_03v3 L=0.28U W=2.5U AS=1.25P
+ AD=1.25P PS=6U PD=6U
M$174 VDD|VDD_DIV \$599 \$856 VDD|VDD_DIV pfet_03v3 L=0.28U W=2.5U AS=1.25P
+ AD=1.25P PS=6U PD=6U
M$175 VDD|VDD_DIV \$856 \$602 VDD|VDD_DIV pfet_03v3 L=0.28U W=2.5U AS=1.25P
+ AD=1.25P PS=6U PD=6U
M$176 VDD|VDD_DIV CK4|CKIN|CKOUT \$603 VDD|VDD_DIV pfet_03v3 L=0.28U W=2.5U
+ AS=1.25P AD=1.25P PS=6U PD=6U
M$177 VDD|VDD_DIV \$603 \$604 VDD|VDD_DIV pfet_03v3 L=0.28U W=2.5U AS=1.25P
+ AD=1.25P PS=6U PD=6U
M$178 \$602 \$604 \$891 VDD|VDD_DIV pfet_03v3 L=0.28U W=2.5U AS=1.25P AD=1.25P
+ PS=6U PD=6U
M$179 VDD|VDD_DIV \$891 \$605 VDD|VDD_DIV pfet_03v3 L=0.28U W=2.5U AS=1.25P
+ AD=1.25P PS=6U PD=6U
M$180 VDD|VDD_DIV \$605 \$606 VDD|VDD_DIV pfet_03v3 L=0.28U W=2.5U AS=1.25P
+ AD=1.25P PS=6U PD=6U
M$181 \$606 \$603 \$891 VDD|VDD_DIV pfet_03v3 L=0.28U W=2.5U AS=1.25P AD=1.25P
+ PS=6U PD=6U
M$182 \$605 \$603 \$607 VDD|VDD_DIV pfet_03v3 L=0.28U W=2.5U AS=1.25P AD=1.25P
+ PS=6U PD=6U
M$183 VDD|VDD_DIV \$607 MO4|MODOUT VDD|VDD_DIV pfet_03v3 L=0.28U W=2.5U
+ AS=1.25P AD=1.25P PS=6U PD=6U
M$184 VDD|VDD_DIV MO4|MODOUT \$608 VDD|VDD_DIV pfet_03v3 L=0.28U W=2.5U
+ AS=1.25P AD=1.25P PS=6U PD=6U
M$185 \$608 \$604 \$607 VDD|VDD_DIV pfet_03v3 L=0.28U W=2.5U AS=1.25P AD=1.25P
+ PS=6U PD=6U
M$186 XNR4_PMID SEL4 NMI4 VDD|VDD_DIV pfet_03v3 L=0.28U W=5U AS=2.5P AD=2.5P
+ PS=11U PD=11U
M$187 VDD|VDD_DIV NMI4 MI4|MODIN VDD|VDD_DIV pfet_03v3 L=0.28U W=2.5U AS=1.25P
+ AD=1.25P PS=6U PD=6U
M$188 VDD|VDD_DIV CK5|CKIN|CKOUT T4 VDD|VDD_DIV pfet_03v3 L=0.28U W=2.5U
+ AS=1.25P AD=1.25P PS=6U PD=6U
M$189 VDD|VDD_DIV SEL4 T4 VDD|VDD_DIV pfet_03v3 L=0.28U W=2.5U AS=1.25P
+ AD=1.25P PS=6U PD=6U
M$190 VDD|VDD_DIV MODIN|SEL5 \$881 VDD|VDD_DIV pfet_03v3 L=0.28U W=2.5U
+ AS=1.25P AD=1.25P PS=6U PD=6U
M$191 VDD|VDD_DIV P|P5 \$881 VDD|VDD_DIV pfet_03v3 L=0.28U W=2.5U AS=1.25P
+ AD=1.25P PS=6U PD=6U
M$192 VDD|VDD_DIV MO5|MODOUT \$881 VDD|VDD_DIV pfet_03v3 L=0.28U W=2.5U
+ AS=1.25P AD=1.25P PS=6U PD=6U
M$193 VDD|VDD_DIV \$861 \$862 VDD|VDD_DIV pfet_03v3 L=0.28U W=2.5U AS=1.25P
+ AD=1.25P PS=6U PD=6U
M$194 VDD|VDD_DIV \$881 \$862 VDD|VDD_DIV pfet_03v3 L=0.28U W=2.5U AS=1.25P
+ AD=1.25P PS=6U PD=6U
M$195 VDD|VDD_DIV \$862 \$613 VDD|VDD_DIV pfet_03v3 L=0.28U W=2.5U AS=1.25P
+ AD=1.25P PS=6U PD=6U
M$196 VDD|VDD_DIV CK5|CKIN|CKOUT \$893 VDD|VDD_DIV pfet_03v3 L=0.28U W=2.5U
+ AS=1.25P AD=1.25P PS=6U PD=6U
M$197 VDD|VDD_DIV \$893 \$614 VDD|VDD_DIV pfet_03v3 L=0.28U W=2.5U AS=1.25P
+ AD=1.25P PS=6U PD=6U
M$198 \$613 \$614 \$615 VDD|VDD_DIV pfet_03v3 L=0.28U W=2.5U AS=1.25P AD=1.25P
+ PS=6U PD=6U
M$199 VDD|VDD_DIV \$615 \$894 VDD|VDD_DIV pfet_03v3 L=0.28U W=2.5U AS=1.25P
+ AD=1.25P PS=6U PD=6U
M$200 VDD|VDD_DIV \$894 \$616 VDD|VDD_DIV pfet_03v3 L=0.28U W=2.5U AS=1.25P
+ AD=1.25P PS=6U PD=6U
M$201 \$616 \$893 \$615 VDD|VDD_DIV pfet_03v3 L=0.28U W=2.5U AS=1.25P AD=1.25P
+ PS=6U PD=6U
M$202 \$894 \$893 \$617 VDD|VDD_DIV pfet_03v3 L=0.28U W=2.5U AS=1.25P AD=1.25P
+ PS=6U PD=6U
M$203 VDD|VDD_DIV \$617 \$618 VDD|VDD_DIV pfet_03v3 L=0.28U W=2.5U AS=1.25P
+ AD=1.25P PS=6U PD=6U
M$204 VDD|VDD_DIV \$618 \$861 VDD|VDD_DIV pfet_03v3 L=0.28U W=2.5U AS=1.25P
+ AD=1.25P PS=6U PD=6U
M$205 \$861 \$614 \$617 VDD|VDD_DIV pfet_03v3 L=0.28U W=2.5U AS=1.25P AD=1.25P
+ PS=6U PD=6U
M$206 VDD|VDD_DIV \$861 CK6|CKOUT VDD|VDD_DIV pfet_03v3 L=0.28U W=5U AS=2.5P
+ AD=2.5P PS=11U PD=11U
M$207 VDD|VDD_DIV MODIN|SEL5 \$863 VDD|VDD_DIV pfet_03v3 L=0.28U W=2.5U
+ AS=1.25P AD=1.25P PS=6U PD=6U
M$208 VDD|VDD_DIV \$618 \$863 VDD|VDD_DIV pfet_03v3 L=0.28U W=2.5U AS=1.25P
+ AD=1.25P PS=6U PD=6U
M$209 VDD|VDD_DIV \$863 \$621 VDD|VDD_DIV pfet_03v3 L=0.28U W=2.5U AS=1.25P
+ AD=1.25P PS=6U PD=6U
M$210 VDD|VDD_DIV CK5|CKIN|CKOUT \$622 VDD|VDD_DIV pfet_03v3 L=0.28U W=2.5U
+ AS=1.25P AD=1.25P PS=6U PD=6U
M$211 VDD|VDD_DIV \$622 \$623 VDD|VDD_DIV pfet_03v3 L=0.28U W=2.5U AS=1.25P
+ AD=1.25P PS=6U PD=6U
M$212 \$621 \$623 \$624 VDD|VDD_DIV pfet_03v3 L=0.28U W=2.5U AS=1.25P AD=1.25P
+ PS=6U PD=6U
M$213 VDD|VDD_DIV \$624 \$625 VDD|VDD_DIV pfet_03v3 L=0.28U W=2.5U AS=1.25P
+ AD=1.25P PS=6U PD=6U
M$214 VDD|VDD_DIV \$625 \$626 VDD|VDD_DIV pfet_03v3 L=0.28U W=2.5U AS=1.25P
+ AD=1.25P PS=6U PD=6U
M$215 \$626 \$622 \$624 VDD|VDD_DIV pfet_03v3 L=0.28U W=2.5U AS=1.25P AD=1.25P
+ PS=6U PD=6U
M$216 \$625 \$622 \$627 VDD|VDD_DIV pfet_03v3 L=0.28U W=2.5U AS=1.25P AD=1.25P
+ PS=6U PD=6U
M$217 VDD|VDD_DIV \$627 MO5|MODOUT VDD|VDD_DIV pfet_03v3 L=0.28U W=2.5U
+ AS=1.25P AD=1.25P PS=6U PD=6U
M$218 VDD|VDD_DIV MO5|MODOUT \$628 VDD|VDD_DIV pfet_03v3 L=0.28U W=2.5U
+ AS=1.25P AD=1.25P PS=6U PD=6U
M$219 \$628 \$623 \$627 VDD|VDD_DIV pfet_03v3 L=0.28U W=2.5U AS=1.25P AD=1.25P
+ PS=6U PD=6U
M$220 VDD|VDD_DIV CK6|CKOUT T5 VDD|VDD_DIV pfet_03v3 L=0.28U W=2.5U AS=1.25P
+ AD=1.25P PS=6U PD=6U
M$221 VDD|VDD_DIV MODIN|SEL5 T5 VDD|VDD_DIV pfet_03v3 L=0.28U W=2.5U AS=1.25P
+ AD=1.25P PS=6U PD=6U
M$222 VDD|VDD_DIV T3 MB VDD|VDD_DIV pfet_03v3 L=0.28U W=2.5U AS=1.25P AD=1.25P
+ PS=6U PD=6U
M$223 VDD|VDD_DIV T4 MB VDD|VDD_DIV pfet_03v3 L=0.28U W=2.5U AS=1.25P AD=1.25P
+ PS=6U PD=6U
M$224 VDD|VDD_DIV T5 MB VDD|VDD_DIV pfet_03v3 L=0.28U W=2.5U AS=1.25P AD=1.25P
+ PS=6U PD=6U
M$225 VDD|VDD_DIV MO4|MODOUT XNR3_PMID VDD|VDD_DIV pfet_03v3 L=0.28U W=5U
+ AS=2.5P AD=2.5P PS=11U PD=11U
M$226 VDD|VDD_DIV MO5|MODOUT XNR4_PMID VDD|VDD_DIV pfet_03v3 L=0.28U W=5U
+ AS=2.5P AD=2.5P PS=11U PD=11U
M$227 DIVOUTB MA VSS VSS nfet_03v3 L=0.28U W=1U AS=0.5P AD=0.5P PS=3U PD=3U
M$228 DIVOUTB MB VSS VSS nfet_03v3 L=0.28U W=1U AS=0.5P AD=0.5P PS=3U PD=3U
M$229 DIVOUT DIVOUTB VSS VSS nfet_03v3 L=0.28U W=2U AS=1P AD=1P PS=5U PD=5U
M$230 \$11 MO0|MODOUT VSS VSS nfet_03v3 L=0.28U W=3U AS=1.5P AD=1.5P PS=7U PD=7U
M$231 \$16 \$13 VSS VSS nfet_03v3 L=0.28U W=2U AS=1P AD=1P PS=5U PD=5U
M$232 \$18 \$17 VSS VSS nfet_03v3 L=0.28U W=1U AS=0.5P AD=0.5P PS=3U PD=3U
M$233 \$19 CKIN|VCO VSS VSS nfet_03v3 L=0.28U W=1U AS=0.5P AD=0.5P PS=3U PD=3U
M$234 \$20 \$19 VSS VSS nfet_03v3 L=0.28U W=1U AS=0.5P AD=0.5P PS=3U PD=3U
M$235 \$21 \$19 \$18 VSS nfet_03v3 L=0.28U W=1U AS=0.5P AD=0.5P PS=3U PD=3U
M$236 \$22 \$21 VSS VSS nfet_03v3 L=0.28U W=1U AS=0.5P AD=0.5P PS=3U PD=3U
M$237 \$23 \$22 VSS VSS nfet_03v3 L=0.28U W=1U AS=0.5P AD=0.5P PS=3U PD=3U
M$238 \$21 \$20 \$23 VSS nfet_03v3 L=0.28U W=1U AS=0.5P AD=0.5P PS=3U PD=3U
M$239 \$24 \$20 \$22 VSS nfet_03v3 L=0.28U W=1U AS=0.5P AD=0.5P PS=3U PD=3U
M$240 \$25 \$24 VSS VSS nfet_03v3 L=0.28U W=1U AS=0.5P AD=0.5P PS=3U PD=3U
M$241 \$15 \$25 VSS VSS nfet_03v3 L=0.28U W=1U AS=0.5P AD=0.5P PS=3U PD=3U
M$242 \$24 \$19 \$15 VSS nfet_03v3 L=0.28U W=1U AS=0.5P AD=0.5P PS=3U PD=3U
M$243 CK1|CKIN|CKOUT \$15 VSS VSS nfet_03v3 L=0.28U W=2U AS=1P AD=1P PS=5U PD=5U
M$244 \$27 \$25 VSS VSS nfet_03v3 L=0.28U W=2U AS=1P AD=1P PS=5U PD=5U
M$245 \$29 \$28 VSS VSS nfet_03v3 L=0.28U W=1U AS=0.5P AD=0.5P PS=3U PD=3U
M$246 \$30 CKIN|VCO VSS VSS nfet_03v3 L=0.28U W=1U AS=0.5P AD=0.5P PS=3U PD=3U
M$247 \$31 \$30 VSS VSS nfet_03v3 L=0.28U W=1U AS=0.5P AD=0.5P PS=3U PD=3U
M$248 \$32 \$30 \$29 VSS nfet_03v3 L=0.28U W=1U AS=0.5P AD=0.5P PS=3U PD=3U
M$249 \$33 \$32 VSS VSS nfet_03v3 L=0.28U W=1U AS=0.5P AD=0.5P PS=3U PD=3U
M$250 \$34 \$33 VSS VSS nfet_03v3 L=0.28U W=1U AS=0.5P AD=0.5P PS=3U PD=3U
M$251 \$32 \$31 \$34 VSS nfet_03v3 L=0.28U W=1U AS=0.5P AD=0.5P PS=3U PD=3U
M$252 \$35 \$31 \$33 VSS nfet_03v3 L=0.28U W=1U AS=0.5P AD=0.5P PS=3U PD=3U
M$253 MO0|MODOUT \$35 VSS VSS nfet_03v3 L=0.28U W=1U AS=0.5P AD=0.5P PS=3U PD=3U
M$254 \$36 MO0|MODOUT VSS VSS nfet_03v3 L=0.28U W=1U AS=0.5P AD=0.5P PS=3U PD=3U
M$255 \$35 \$30 \$36 VSS nfet_03v3 L=0.28U W=1U AS=0.5P AD=0.5P PS=3U PD=3U
M$256 NMI0 MO1|MODOUT VSS VSS nfet_03v3 L=0.28U W=1U AS=0.5P AD=0.5P PS=3U PD=3U
M$257 NMI0 SEL0 VSS VSS nfet_03v3 L=0.28U W=1U AS=0.5P AD=0.5P PS=3U PD=3U
M$258 MI0|MODIN NMI0 VSS VSS nfet_03v3 L=0.28U W=1U AS=0.5P AD=0.5P PS=3U PD=3U
M$259 XM0_NMID SEL0 VSS VSS nfet_03v3 L=0.28U W=2U AS=1P AD=1P PS=5U PD=5U
M$260 \$44 MO1|MODOUT VSS VSS nfet_03v3 L=0.28U W=3U AS=1.5P AD=1.5P PS=7U PD=7U
M$261 \$47 \$43 VSS VSS nfet_03v3 L=0.28U W=2U AS=1P AD=1P PS=5U PD=5U
M$262 \$48 \$46 VSS VSS nfet_03v3 L=0.28U W=1U AS=0.5P AD=0.5P PS=3U PD=3U
M$263 \$49 CK1|CKIN|CKOUT VSS VSS nfet_03v3 L=0.28U W=1U AS=0.5P AD=0.5P PS=3U
+ PD=3U
M$264 \$50 \$49 VSS VSS nfet_03v3 L=0.28U W=1U AS=0.5P AD=0.5P PS=3U PD=3U
M$265 \$51 \$49 \$48 VSS nfet_03v3 L=0.28U W=1U AS=0.5P AD=0.5P PS=3U PD=3U
M$266 \$52 \$51 VSS VSS nfet_03v3 L=0.28U W=1U AS=0.5P AD=0.5P PS=3U PD=3U
M$267 \$53 \$52 VSS VSS nfet_03v3 L=0.28U W=1U AS=0.5P AD=0.5P PS=3U PD=3U
M$268 \$51 \$50 \$53 VSS nfet_03v3 L=0.28U W=1U AS=0.5P AD=0.5P PS=3U PD=3U
M$269 \$54 \$50 \$52 VSS nfet_03v3 L=0.28U W=1U AS=0.5P AD=0.5P PS=3U PD=3U
M$270 \$55 \$54 VSS VSS nfet_03v3 L=0.28U W=1U AS=0.5P AD=0.5P PS=3U PD=3U
M$271 \$45 \$55 VSS VSS nfet_03v3 L=0.28U W=1U AS=0.5P AD=0.5P PS=3U PD=3U
M$272 \$54 \$49 \$45 VSS nfet_03v3 L=0.28U W=1U AS=0.5P AD=0.5P PS=3U PD=3U
M$273 CK2|CKIN|CKOUT \$45 VSS VSS nfet_03v3 L=0.28U W=2U AS=1P AD=1P PS=5U PD=5U
M$274 \$58 \$55 VSS VSS nfet_03v3 L=0.28U W=2U AS=1P AD=1P PS=5U PD=5U
M$275 \$59 \$57 VSS VSS nfet_03v3 L=0.28U W=1U AS=0.5P AD=0.5P PS=3U PD=3U
M$276 \$60 CK1|CKIN|CKOUT VSS VSS nfet_03v3 L=0.28U W=1U AS=0.5P AD=0.5P PS=3U
+ PD=3U
M$277 \$61 \$60 VSS VSS nfet_03v3 L=0.28U W=1U AS=0.5P AD=0.5P PS=3U PD=3U
M$278 \$62 \$60 \$59 VSS nfet_03v3 L=0.28U W=1U AS=0.5P AD=0.5P PS=3U PD=3U
M$279 \$63 \$62 VSS VSS nfet_03v3 L=0.28U W=1U AS=0.5P AD=0.5P PS=3U PD=3U
M$280 \$64 \$63 VSS VSS nfet_03v3 L=0.28U W=1U AS=0.5P AD=0.5P PS=3U PD=3U
M$281 \$62 \$61 \$64 VSS nfet_03v3 L=0.28U W=1U AS=0.5P AD=0.5P PS=3U PD=3U
M$282 \$65 \$61 \$63 VSS nfet_03v3 L=0.28U W=1U AS=0.5P AD=0.5P PS=3U PD=3U
M$283 MO1|MODOUT \$65 VSS VSS nfet_03v3 L=0.28U W=1U AS=0.5P AD=0.5P PS=3U PD=3U
M$284 \$66 MO1|MODOUT VSS VSS nfet_03v3 L=0.28U W=1U AS=0.5P AD=0.5P PS=3U PD=3U
M$285 \$65 \$60 \$66 VSS nfet_03v3 L=0.28U W=1U AS=0.5P AD=0.5P PS=3U PD=3U
M$286 NMI1 MO2|MODOUT VSS VSS nfet_03v3 L=0.28U W=1U AS=0.5P AD=0.5P PS=3U PD=3U
M$287 NMI1 SEL1 VSS VSS nfet_03v3 L=0.28U W=1U AS=0.5P AD=0.5P PS=3U PD=3U
M$288 MI1|MODIN NMI1 VSS VSS nfet_03v3 L=0.28U W=1U AS=0.5P AD=0.5P PS=3U PD=3U
M$289 XM1_NMID SEL1 VSS VSS nfet_03v3 L=0.28U W=2U AS=1P AD=1P PS=5U PD=5U
M$290 \$73 MO2|MODOUT VSS VSS nfet_03v3 L=0.28U W=3U AS=1.5P AD=1.5P PS=7U PD=7U
M$291 \$77 \$74 VSS VSS nfet_03v3 L=0.28U W=2U AS=1P AD=1P PS=5U PD=5U
M$292 \$78 \$76 VSS VSS nfet_03v3 L=0.28U W=1U AS=0.5P AD=0.5P PS=3U PD=3U
M$293 \$79 CK2|CKIN|CKOUT VSS VSS nfet_03v3 L=0.28U W=1U AS=0.5P AD=0.5P PS=3U
+ PD=3U
M$294 \$80 \$79 VSS VSS nfet_03v3 L=0.28U W=1U AS=0.5P AD=0.5P PS=3U PD=3U
M$295 \$81 \$79 \$78 VSS nfet_03v3 L=0.28U W=1U AS=0.5P AD=0.5P PS=3U PD=3U
M$296 \$82 \$81 VSS VSS nfet_03v3 L=0.28U W=1U AS=0.5P AD=0.5P PS=3U PD=3U
M$297 \$83 \$82 VSS VSS nfet_03v3 L=0.28U W=1U AS=0.5P AD=0.5P PS=3U PD=3U
M$298 \$81 \$80 \$83 VSS nfet_03v3 L=0.28U W=1U AS=0.5P AD=0.5P PS=3U PD=3U
M$299 \$84 \$80 \$82 VSS nfet_03v3 L=0.28U W=1U AS=0.5P AD=0.5P PS=3U PD=3U
M$300 \$85 \$84 VSS VSS nfet_03v3 L=0.28U W=1U AS=0.5P AD=0.5P PS=3U PD=3U
M$301 \$75 \$85 VSS VSS nfet_03v3 L=0.28U W=1U AS=0.5P AD=0.5P PS=3U PD=3U
M$302 \$84 \$79 \$75 VSS nfet_03v3 L=0.28U W=1U AS=0.5P AD=0.5P PS=3U PD=3U
M$303 CK3|CKIN|CKOUT \$75 VSS VSS nfet_03v3 L=0.28U W=2U AS=1P AD=1P PS=5U PD=5U
M$304 \$87 \$85 VSS VSS nfet_03v3 L=0.28U W=2U AS=1P AD=1P PS=5U PD=5U
M$305 \$89 \$88 VSS VSS nfet_03v3 L=0.28U W=1U AS=0.5P AD=0.5P PS=3U PD=3U
M$306 \$90 CK2|CKIN|CKOUT VSS VSS nfet_03v3 L=0.28U W=1U AS=0.5P AD=0.5P PS=3U
+ PD=3U
M$307 \$91 \$90 VSS VSS nfet_03v3 L=0.28U W=1U AS=0.5P AD=0.5P PS=3U PD=3U
M$308 \$92 \$90 \$89 VSS nfet_03v3 L=0.28U W=1U AS=0.5P AD=0.5P PS=3U PD=3U
M$309 \$93 \$92 VSS VSS nfet_03v3 L=0.28U W=1U AS=0.5P AD=0.5P PS=3U PD=3U
M$310 \$94 \$93 VSS VSS nfet_03v3 L=0.28U W=1U AS=0.5P AD=0.5P PS=3U PD=3U
M$311 \$92 \$91 \$94 VSS nfet_03v3 L=0.28U W=1U AS=0.5P AD=0.5P PS=3U PD=3U
M$312 \$95 \$91 \$93 VSS nfet_03v3 L=0.28U W=1U AS=0.5P AD=0.5P PS=3U PD=3U
M$313 MO2|MODOUT \$95 VSS VSS nfet_03v3 L=0.28U W=1U AS=0.5P AD=0.5P PS=3U PD=3U
M$314 \$96 MO2|MODOUT VSS VSS nfet_03v3 L=0.28U W=1U AS=0.5P AD=0.5P PS=3U PD=3U
M$315 \$95 \$90 \$96 VSS nfet_03v3 L=0.28U W=1U AS=0.5P AD=0.5P PS=3U PD=3U
M$316 NMI2 MO3|MODOUT VSS VSS nfet_03v3 L=0.28U W=1U AS=0.5P AD=0.5P PS=3U PD=3U
M$317 NMI2 SEL2 VSS VSS nfet_03v3 L=0.28U W=1U AS=0.5P AD=0.5P PS=3U PD=3U
M$318 MI2|MODIN NMI2 VSS VSS nfet_03v3 L=0.28U W=1U AS=0.5P AD=0.5P PS=3U PD=3U
M$319 XM2_NMID SEL2 VSS VSS nfet_03v3 L=0.28U W=2U AS=1P AD=1P PS=5U PD=5U
M$320 XMA_NM2 T2 VSS VSS nfet_03v3 L=0.28U W=3U AS=1.5P AD=1.5P PS=7U PD=7U
M$321 \$12 P|P0 \$11 VSS nfet_03v3 L=0.28U W=3U AS=1.5P AD=1.5P PS=7U PD=7U
M$322 \$13 MI0|MODIN \$12 VSS nfet_03v3 L=0.28U W=3U AS=1.5P AD=1.5P PS=7U PD=7U
M$323 \$17 \$15 \$16 VSS nfet_03v3 L=0.28U W=2U AS=1P AD=1P PS=5U PD=5U
M$324 \$28 MI0|MODIN \$27 VSS nfet_03v3 L=0.28U W=2U AS=1P AD=1P PS=5U PD=5U
M$325 T0 CK1|CKIN|CKOUT XM0_NMID VSS nfet_03v3 L=0.28U W=2U AS=1P AD=1P PS=5U
+ PD=5U
M$326 \$43 MI1|MODIN \$42 VSS nfet_03v3 L=0.28U W=3U AS=1.5P AD=1.5P PS=7U PD=7U
M$327 \$42 P|P1 \$44 VSS nfet_03v3 L=0.28U W=3U AS=1.5P AD=1.5P PS=7U PD=7U
M$328 \$46 \$45 \$47 VSS nfet_03v3 L=0.28U W=2U AS=1P AD=1P PS=5U PD=5U
M$329 \$57 MI1|MODIN \$58 VSS nfet_03v3 L=0.28U W=2U AS=1P AD=1P PS=5U PD=5U
M$330 T1 CK2|CKIN|CKOUT XM1_NMID VSS nfet_03v3 L=0.28U W=2U AS=1P AD=1P PS=5U
+ PD=5U
M$331 \$72 P|P2 \$73 VSS nfet_03v3 L=0.28U W=3U AS=1.5P AD=1.5P PS=7U PD=7U
M$332 \$74 MI2|MODIN \$72 VSS nfet_03v3 L=0.28U W=3U AS=1.5P AD=1.5P PS=7U PD=7U
M$333 \$76 \$75 \$77 VSS nfet_03v3 L=0.28U W=2U AS=1P AD=1P PS=5U PD=5U
M$334 \$88 MI2|MODIN \$87 VSS nfet_03v3 L=0.28U W=2U AS=1P AD=1P PS=5U PD=5U
M$335 T2 CK3|CKIN|CKOUT XM2_NMID VSS nfet_03v3 L=0.28U W=2U AS=1P AD=1P PS=5U
+ PD=5U
M$336 MA T0 XMA_NM1 VSS nfet_03v3 L=0.28U W=3U AS=1.5P AD=1.5P PS=7U PD=7U
M$337 XMA_NM1 T1 XMA_NM2 VSS nfet_03v3 L=0.28U W=3U AS=1.5P AD=1.5P PS=7U PD=7U
M$338 XFRT_CKB CKIN|VCO VSS VSS nfet_03v3 L=0.28U W=1U AS=0.5P AD=0.5P PS=3U
+ PD=3U
M$339 XFRT_CKBB XFRT_CKB VSS VSS nfet_03v3 L=0.28U W=1U AS=0.5P AD=0.5P PS=3U
+ PD=3U
M$340 XFRT_NM XFRT_CKB DIVOUT VSS nfet_03v3 L=0.28U W=1U AS=0.5P AD=0.5P PS=3U
+ PD=3U
M$341 XFRT_NMA XFRT_NM VSS VSS nfet_03v3 L=0.28U W=1U AS=0.5P AD=0.5P PS=3U
+ PD=3U
M$342 XFRT_NMB XFRT_NMA VSS VSS nfet_03v3 L=0.28U W=1U AS=0.5P AD=0.5P PS=3U
+ PD=3U
M$343 XFRT_NM XFRT_CKBB XFRT_NMB VSS nfet_03v3 L=0.28U W=1U AS=0.5P AD=0.5P
+ PS=3U PD=3U
M$344 XFRT_NS XFRT_CKBB XFRT_NMA VSS nfet_03v3 L=0.28U W=1U AS=0.5P AD=0.5P
+ PS=3U PD=3U
M$345 FB XFRT_NS VSS VSS nfet_03v3 L=0.28U W=1U AS=0.5P AD=0.5P PS=3U PD=3U
M$346 FBB FB VSS VSS nfet_03v3 L=0.28U W=1U AS=0.5P AD=0.5P PS=3U PD=3U
M$347 XFRT_NS XFRT_CKB FBB VSS nfet_03v3 L=0.28U W=1U AS=0.5P AD=0.5P PS=3U
+ PD=3U
M$348 \$572 MO3|MODOUT VSS VSS nfet_03v3 L=0.28U W=3U AS=1.5P AD=1.5P PS=7U
+ PD=7U
M$349 \$573 \$879 VSS VSS nfet_03v3 L=0.28U W=2U AS=1P AD=1P PS=5U PD=5U
M$350 \$574 \$848 VSS VSS nfet_03v3 L=0.28U W=1U AS=0.5P AD=0.5P PS=3U PD=3U
M$351 \$575 CK3|CKIN|CKOUT VSS VSS nfet_03v3 L=0.28U W=1U AS=0.5P AD=0.5P PS=3U
+ PD=3U
M$352 \$576 \$575 VSS VSS nfet_03v3 L=0.28U W=1U AS=0.5P AD=0.5P PS=3U PD=3U
M$353 \$886 \$575 \$574 VSS nfet_03v3 L=0.28U W=1U AS=0.5P AD=0.5P PS=3U PD=3U
M$354 \$577 \$886 VSS VSS nfet_03v3 L=0.28U W=1U AS=0.5P AD=0.5P PS=3U PD=3U
M$355 \$578 \$577 VSS VSS nfet_03v3 L=0.28U W=1U AS=0.5P AD=0.5P PS=3U PD=3U
M$356 \$886 \$576 \$578 VSS nfet_03v3 L=0.28U W=1U AS=0.5P AD=0.5P PS=3U PD=3U
M$357 \$579 \$576 \$577 VSS nfet_03v3 L=0.28U W=1U AS=0.5P AD=0.5P PS=3U PD=3U
M$358 \$580 \$579 VSS VSS nfet_03v3 L=0.28U W=1U AS=0.5P AD=0.5P PS=3U PD=3U
M$359 \$847 \$580 VSS VSS nfet_03v3 L=0.28U W=1U AS=0.5P AD=0.5P PS=3U PD=3U
M$360 \$579 \$575 \$847 VSS nfet_03v3 L=0.28U W=1U AS=0.5P AD=0.5P PS=3U PD=3U
M$361 CK4|CKIN|CKOUT \$847 VSS VSS nfet_03v3 L=0.28U W=2U AS=1P AD=1P PS=5U
+ PD=5U
M$362 \$582 \$580 VSS VSS nfet_03v3 L=0.28U W=2U AS=1P AD=1P PS=5U PD=5U
M$363 \$583 \$849 VSS VSS nfet_03v3 L=0.28U W=1U AS=0.5P AD=0.5P PS=3U PD=3U
M$364 \$584 CK3|CKIN|CKOUT VSS VSS nfet_03v3 L=0.28U W=1U AS=0.5P AD=0.5P PS=3U
+ PD=3U
M$365 \$585 \$584 VSS VSS nfet_03v3 L=0.28U W=1U AS=0.5P AD=0.5P PS=3U PD=3U
M$366 \$887 \$584 \$583 VSS nfet_03v3 L=0.28U W=1U AS=0.5P AD=0.5P PS=3U PD=3U
M$367 \$586 \$887 VSS VSS nfet_03v3 L=0.28U W=1U AS=0.5P AD=0.5P PS=3U PD=3U
M$368 \$888 \$586 VSS VSS nfet_03v3 L=0.28U W=1U AS=0.5P AD=0.5P PS=3U PD=3U
M$369 \$887 \$585 \$888 VSS nfet_03v3 L=0.28U W=1U AS=0.5P AD=0.5P PS=3U PD=3U
M$370 \$587 \$585 \$586 VSS nfet_03v3 L=0.28U W=1U AS=0.5P AD=0.5P PS=3U PD=3U
M$371 MO3|MODOUT \$587 VSS VSS nfet_03v3 L=0.28U W=1U AS=0.5P AD=0.5P PS=3U
+ PD=3U
M$372 \$588 MO3|MODOUT VSS VSS nfet_03v3 L=0.28U W=1U AS=0.5P AD=0.5P PS=3U
+ PD=3U
M$373 \$587 \$584 \$588 VSS nfet_03v3 L=0.28U W=1U AS=0.5P AD=0.5P PS=3U PD=3U
M$374 NMI3 MO4|MODOUT VSS VSS nfet_03v3 L=0.28U W=1U AS=0.5P AD=0.5P PS=3U PD=3U
M$375 NMI3 SEL3 VSS VSS nfet_03v3 L=0.28U W=1U AS=0.5P AD=0.5P PS=3U PD=3U
M$376 MI3|MODIN NMI3 VSS VSS nfet_03v3 L=0.28U W=1U AS=0.5P AD=0.5P PS=3U PD=3U
M$377 XM3_NMID SEL3 VSS VSS nfet_03v3 L=0.28U W=2U AS=1P AD=1P PS=5U PD=5U
M$378 \$591 MO4|MODOUT VSS VSS nfet_03v3 L=0.28U W=3U AS=1.5P AD=1.5P PS=7U
+ PD=7U
M$379 \$592 \$880 VSS VSS nfet_03v3 L=0.28U W=2U AS=1P AD=1P PS=5U PD=5U
M$380 \$593 \$855 VSS VSS nfet_03v3 L=0.28U W=1U AS=0.5P AD=0.5P PS=3U PD=3U
M$381 \$594 CK4|CKIN|CKOUT VSS VSS nfet_03v3 L=0.28U W=1U AS=0.5P AD=0.5P PS=3U
+ PD=3U
M$382 \$890 \$594 VSS VSS nfet_03v3 L=0.28U W=1U AS=0.5P AD=0.5P PS=3U PD=3U
M$383 \$595 \$594 \$593 VSS nfet_03v3 L=0.28U W=1U AS=0.5P AD=0.5P PS=3U PD=3U
M$384 \$596 \$595 VSS VSS nfet_03v3 L=0.28U W=1U AS=0.5P AD=0.5P PS=3U PD=3U
M$385 \$597 \$596 VSS VSS nfet_03v3 L=0.28U W=1U AS=0.5P AD=0.5P PS=3U PD=3U
M$386 \$595 \$890 \$597 VSS nfet_03v3 L=0.28U W=1U AS=0.5P AD=0.5P PS=3U PD=3U
M$387 \$598 \$890 \$596 VSS nfet_03v3 L=0.28U W=1U AS=0.5P AD=0.5P PS=3U PD=3U
M$388 \$599 \$598 VSS VSS nfet_03v3 L=0.28U W=1U AS=0.5P AD=0.5P PS=3U PD=3U
M$389 \$854 \$599 VSS VSS nfet_03v3 L=0.28U W=1U AS=0.5P AD=0.5P PS=3U PD=3U
M$390 \$598 \$594 \$854 VSS nfet_03v3 L=0.28U W=1U AS=0.5P AD=0.5P PS=3U PD=3U
M$391 CK5|CKIN|CKOUT \$854 VSS VSS nfet_03v3 L=0.28U W=2U AS=1P AD=1P PS=5U
+ PD=5U
M$392 \$601 \$599 VSS VSS nfet_03v3 L=0.28U W=2U AS=1P AD=1P PS=5U PD=5U
M$393 \$602 \$856 VSS VSS nfet_03v3 L=0.28U W=1U AS=0.5P AD=0.5P PS=3U PD=3U
M$394 \$603 CK4|CKIN|CKOUT VSS VSS nfet_03v3 L=0.28U W=1U AS=0.5P AD=0.5P PS=3U
+ PD=3U
M$395 \$604 \$603 VSS VSS nfet_03v3 L=0.28U W=1U AS=0.5P AD=0.5P PS=3U PD=3U
M$396 \$891 \$603 \$602 VSS nfet_03v3 L=0.28U W=1U AS=0.5P AD=0.5P PS=3U PD=3U
M$397 \$605 \$891 VSS VSS nfet_03v3 L=0.28U W=1U AS=0.5P AD=0.5P PS=3U PD=3U
M$398 \$606 \$605 VSS VSS nfet_03v3 L=0.28U W=1U AS=0.5P AD=0.5P PS=3U PD=3U
M$399 \$891 \$604 \$606 VSS nfet_03v3 L=0.28U W=1U AS=0.5P AD=0.5P PS=3U PD=3U
M$400 \$607 \$604 \$605 VSS nfet_03v3 L=0.28U W=1U AS=0.5P AD=0.5P PS=3U PD=3U
M$401 MO4|MODOUT \$607 VSS VSS nfet_03v3 L=0.28U W=1U AS=0.5P AD=0.5P PS=3U
+ PD=3U
M$402 \$608 MO4|MODOUT VSS VSS nfet_03v3 L=0.28U W=1U AS=0.5P AD=0.5P PS=3U
+ PD=3U
M$403 \$607 \$603 \$608 VSS nfet_03v3 L=0.28U W=1U AS=0.5P AD=0.5P PS=3U PD=3U
M$404 NMI4 MO5|MODOUT VSS VSS nfet_03v3 L=0.28U W=1U AS=0.5P AD=0.5P PS=3U PD=3U
M$405 NMI4 SEL4 VSS VSS nfet_03v3 L=0.28U W=1U AS=0.5P AD=0.5P PS=3U PD=3U
M$406 MI4|MODIN NMI4 VSS VSS nfet_03v3 L=0.28U W=1U AS=0.5P AD=0.5P PS=3U PD=3U
M$407 XM4_NMID SEL4 VSS VSS nfet_03v3 L=0.28U W=2U AS=1P AD=1P PS=5U PD=5U
M$408 \$611 MO5|MODOUT VSS VSS nfet_03v3 L=0.28U W=3U AS=1.5P AD=1.5P PS=7U
+ PD=7U
M$409 \$612 \$881 VSS VSS nfet_03v3 L=0.28U W=2U AS=1P AD=1P PS=5U PD=5U
M$410 \$613 \$862 VSS VSS nfet_03v3 L=0.28U W=1U AS=0.5P AD=0.5P PS=3U PD=3U
M$411 \$893 CK5|CKIN|CKOUT VSS VSS nfet_03v3 L=0.28U W=1U AS=0.5P AD=0.5P PS=3U
+ PD=3U
M$412 \$614 \$893 VSS VSS nfet_03v3 L=0.28U W=1U AS=0.5P AD=0.5P PS=3U PD=3U
M$413 \$615 \$893 \$613 VSS nfet_03v3 L=0.28U W=1U AS=0.5P AD=0.5P PS=3U PD=3U
M$414 \$894 \$615 VSS VSS nfet_03v3 L=0.28U W=1U AS=0.5P AD=0.5P PS=3U PD=3U
M$415 \$616 \$894 VSS VSS nfet_03v3 L=0.28U W=1U AS=0.5P AD=0.5P PS=3U PD=3U
M$416 \$615 \$614 \$616 VSS nfet_03v3 L=0.28U W=1U AS=0.5P AD=0.5P PS=3U PD=3U
M$417 \$617 \$614 \$894 VSS nfet_03v3 L=0.28U W=1U AS=0.5P AD=0.5P PS=3U PD=3U
M$418 \$618 \$617 VSS VSS nfet_03v3 L=0.28U W=1U AS=0.5P AD=0.5P PS=3U PD=3U
M$419 \$861 \$618 VSS VSS nfet_03v3 L=0.28U W=1U AS=0.5P AD=0.5P PS=3U PD=3U
M$420 \$617 \$893 \$861 VSS nfet_03v3 L=0.28U W=1U AS=0.5P AD=0.5P PS=3U PD=3U
M$421 CK6|CKOUT \$861 VSS VSS nfet_03v3 L=0.28U W=2U AS=1P AD=1P PS=5U PD=5U
M$422 \$620 \$618 VSS VSS nfet_03v3 L=0.28U W=2U AS=1P AD=1P PS=5U PD=5U
M$423 \$621 \$863 VSS VSS nfet_03v3 L=0.28U W=1U AS=0.5P AD=0.5P PS=3U PD=3U
M$424 \$622 CK5|CKIN|CKOUT VSS VSS nfet_03v3 L=0.28U W=1U AS=0.5P AD=0.5P PS=3U
+ PD=3U
M$425 \$623 \$622 VSS VSS nfet_03v3 L=0.28U W=1U AS=0.5P AD=0.5P PS=3U PD=3U
M$426 \$624 \$622 \$621 VSS nfet_03v3 L=0.28U W=1U AS=0.5P AD=0.5P PS=3U PD=3U
M$427 \$625 \$624 VSS VSS nfet_03v3 L=0.28U W=1U AS=0.5P AD=0.5P PS=3U PD=3U
M$428 \$626 \$625 VSS VSS nfet_03v3 L=0.28U W=1U AS=0.5P AD=0.5P PS=3U PD=3U
M$429 \$624 \$623 \$626 VSS nfet_03v3 L=0.28U W=1U AS=0.5P AD=0.5P PS=3U PD=3U
M$430 \$627 \$623 \$625 VSS nfet_03v3 L=0.28U W=1U AS=0.5P AD=0.5P PS=3U PD=3U
M$431 MO5|MODOUT \$627 VSS VSS nfet_03v3 L=0.28U W=1U AS=0.5P AD=0.5P PS=3U
+ PD=3U
M$432 \$628 MO5|MODOUT VSS VSS nfet_03v3 L=0.28U W=1U AS=0.5P AD=0.5P PS=3U
+ PD=3U
M$433 \$627 \$622 \$628 VSS nfet_03v3 L=0.28U W=1U AS=0.5P AD=0.5P PS=3U PD=3U
M$434 XM5_NMID MODIN|SEL5 VSS VSS nfet_03v3 L=0.28U W=2U AS=1P AD=1P PS=5U PD=5U
M$435 XMB_NM2 T5 VSS VSS nfet_03v3 L=0.28U W=3U AS=1.5P AD=1.5P PS=7U PD=7U
M$436 \$846 P|P3 \$572 VSS nfet_03v3 L=0.28U W=3U AS=1.5P AD=1.5P PS=7U PD=7U
M$437 \$879 MI3|MODIN \$846 VSS nfet_03v3 L=0.28U W=3U AS=1.5P AD=1.5P PS=7U
+ PD=7U
M$438 \$848 \$847 \$573 VSS nfet_03v3 L=0.28U W=2U AS=1P AD=1P PS=5U PD=5U
M$439 \$849 MI3|MODIN \$582 VSS nfet_03v3 L=0.28U W=2U AS=1P AD=1P PS=5U PD=5U
M$440 T3 CK4|CKIN|CKOUT XM3_NMID VSS nfet_03v3 L=0.28U W=2U AS=1P AD=1P PS=5U
+ PD=5U
M$441 \$853 P|P4 \$591 VSS nfet_03v3 L=0.28U W=3U AS=1.5P AD=1.5P PS=7U PD=7U
M$442 \$880 MI4|MODIN \$853 VSS nfet_03v3 L=0.28U W=3U AS=1.5P AD=1.5P PS=7U
+ PD=7U
M$443 \$855 \$854 \$592 VSS nfet_03v3 L=0.28U W=2U AS=1P AD=1P PS=5U PD=5U
M$444 \$856 MI4|MODIN \$601 VSS nfet_03v3 L=0.28U W=2U AS=1P AD=1P PS=5U PD=5U
M$445 T4 CK5|CKIN|CKOUT XM4_NMID VSS nfet_03v3 L=0.28U W=2U AS=1P AD=1P PS=5U
+ PD=5U
M$446 \$881 MODIN|SEL5 \$860 VSS nfet_03v3 L=0.28U W=3U AS=1.5P AD=1.5P PS=7U
+ PD=7U
M$447 \$860 P|P5 \$611 VSS nfet_03v3 L=0.28U W=3U AS=1.5P AD=1.5P PS=7U PD=7U
M$448 \$862 \$861 \$612 VSS nfet_03v3 L=0.28U W=2U AS=1P AD=1P PS=5U PD=5U
M$449 \$863 MODIN|SEL5 \$620 VSS nfet_03v3 L=0.28U W=2U AS=1P AD=1P PS=5U PD=5U
M$450 T5 CK6|CKOUT XM5_NMID VSS nfet_03v3 L=0.28U W=2U AS=1P AD=1P PS=5U PD=5U
M$451 MB T3 XMB_NM1 VSS nfet_03v3 L=0.28U W=3U AS=1.5P AD=1.5P PS=7U PD=7U
M$452 XMB_NM1 T4 XMB_NM2 VSS nfet_03v3 L=0.28U W=3U AS=1.5P AD=1.5P PS=7U PD=7U
.ENDS divider_chain
