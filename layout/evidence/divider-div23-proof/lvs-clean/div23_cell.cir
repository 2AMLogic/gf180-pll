* Extracted by KLayout with GF180MCU LVS runset on : 09/09/2026 02:12

.SUBCKT div23_cell VSS MODOUT CKIN CKOUT MODIN P VDD
M$1 VDD \$61 \$19 VDD pfet_03v3 L=0.28U W=2.5U AS=1.25P AD=1.25P PS=6U PD=6U
M$2 VDD \$19 \$20 VDD pfet_03v3 L=0.28U W=2.5U AS=1.25P AD=1.25P PS=6U PD=6U
M$3 VDD \$17 \$18 VDD pfet_03v3 L=0.28U W=2.5U AS=1.25P AD=1.25P PS=6U PD=6U
M$4 VDD \$10 \$11 VDD pfet_03v3 L=0.28U W=2.5U AS=1.25P AD=1.25P PS=6U PD=6U
M$5 VDD \$58 CKOUT VDD pfet_03v3 L=0.28U W=5U AS=2.5P AD=2.5P PS=11U PD=11U
M$6 \$58 \$8 \$12 VDD pfet_03v3 L=0.28U W=2.5U AS=1.25P AD=1.25P PS=6U PD=6U
M$7 VDD \$59 \$5 VDD pfet_03v3 L=0.28U W=2.5U AS=1.25P AD=1.25P PS=6U PD=6U
M$8 VDD \$13 \$58 VDD pfet_03v3 L=0.28U W=2.5U AS=1.25P AD=1.25P PS=6U PD=6U
M$9 VDD P \$56 VDD pfet_03v3 L=0.28U W=2.5U AS=1.25P AD=1.25P PS=6U PD=6U
M$10 VDD MODOUT \$56 VDD pfet_03v3 L=0.28U W=2.5U AS=1.25P AD=1.25P PS=6U PD=6U
M$11 VDD \$12 \$13 VDD pfet_03v3 L=0.28U W=2.5U AS=1.25P AD=1.25P PS=6U PD=6U
M$12 VDD \$58 \$59 VDD pfet_03v3 L=0.28U W=2.5U AS=1.25P AD=1.25P PS=6U PD=6U
M$13 VDD CKIN \$7 VDD pfet_03v3 L=0.28U W=2.5U AS=1.25P AD=1.25P PS=6U PD=6U
M$14 VDD MODIN \$56 VDD pfet_03v3 L=0.28U W=2.5U AS=1.25P AD=1.25P PS=6U PD=6U
M$15 VDD \$21 MODOUT VDD pfet_03v3 L=0.28U W=2.5U AS=1.25P AD=1.25P PS=6U PD=6U
M$16 \$22 \$18 \$21 VDD pfet_03v3 L=0.28U W=2.5U AS=1.25P AD=1.25P PS=6U PD=6U
M$17 \$19 \$17 \$21 VDD pfet_03v3 L=0.28U W=2.5U AS=1.25P AD=1.25P PS=6U PD=6U
M$18 VDD \$7 \$8 VDD pfet_03v3 L=0.28U W=2.5U AS=1.25P AD=1.25P PS=6U PD=6U
M$19 VDD \$9 \$10 VDD pfet_03v3 L=0.28U W=2.5U AS=1.25P AD=1.25P PS=6U PD=6U
M$20 VDD CKIN \$17 VDD pfet_03v3 L=0.28U W=2.5U AS=1.25P AD=1.25P PS=6U PD=6U
M$21 \$10 \$7 \$12 VDD pfet_03v3 L=0.28U W=2.5U AS=1.25P AD=1.25P PS=6U PD=6U
M$22 VDD \$56 \$59 VDD pfet_03v3 L=0.28U W=2.5U AS=1.25P AD=1.25P PS=6U PD=6U
M$23 VDD \$60 \$16 VDD pfet_03v3 L=0.28U W=2.5U AS=1.25P AD=1.25P PS=6U PD=6U
M$24 \$5 \$8 \$9 VDD pfet_03v3 L=0.28U W=2.5U AS=1.25P AD=1.25P PS=6U PD=6U
M$25 \$16 \$18 \$61 VDD pfet_03v3 L=0.28U W=2.5U AS=1.25P AD=1.25P PS=6U PD=6U
M$26 \$20 \$17 \$61 VDD pfet_03v3 L=0.28U W=2.5U AS=1.25P AD=1.25P PS=6U PD=6U
M$27 \$11 \$7 \$9 VDD pfet_03v3 L=0.28U W=2.5U AS=1.25P AD=1.25P PS=6U PD=6U
M$28 VDD MODOUT \$22 VDD pfet_03v3 L=0.28U W=2.5U AS=1.25P AD=1.25P PS=6U PD=6U
M$29 VDD \$13 \$60 VDD pfet_03v3 L=0.28U W=2.5U AS=1.25P AD=1.25P PS=6U PD=6U
M$30 VDD MODIN \$60 VDD pfet_03v3 L=0.28U W=2.5U AS=1.25P AD=1.25P PS=6U PD=6U
M$31 \$61 \$17 \$16 VSS nfet_03v3 L=0.28U W=1U AS=0.5P AD=0.5P PS=3U PD=3U
M$32 \$7 CKIN VSS VSS nfet_03v3 L=0.28U W=1U AS=0.5P AD=0.5P PS=3U PD=3U
M$33 \$4 \$56 VSS VSS nfet_03v3 L=0.28U W=2U AS=1P AD=1P PS=5U PD=5U
M$34 \$20 \$19 VSS VSS nfet_03v3 L=0.28U W=1U AS=0.5P AD=0.5P PS=3U PD=3U
M$35 \$9 \$8 \$11 VSS nfet_03v3 L=0.28U W=1U AS=0.5P AD=0.5P PS=3U PD=3U
M$36 \$19 \$61 VSS VSS nfet_03v3 L=0.28U W=1U AS=0.5P AD=0.5P PS=3U PD=3U
M$37 \$15 \$13 VSS VSS nfet_03v3 L=0.28U W=2U AS=1P AD=1P PS=5U PD=5U
M$38 \$61 \$18 \$20 VSS nfet_03v3 L=0.28U W=1U AS=0.5P AD=0.5P PS=3U PD=3U
M$39 \$17 CKIN VSS VSS nfet_03v3 L=0.28U W=1U AS=0.5P AD=0.5P PS=3U PD=3U
M$40 \$16 \$60 VSS VSS nfet_03v3 L=0.28U W=1U AS=0.5P AD=0.5P PS=3U PD=3U
M$41 \$9 \$7 \$5 VSS nfet_03v3 L=0.28U W=1U AS=0.5P AD=0.5P PS=3U PD=3U
M$42 \$21 \$17 \$22 VSS nfet_03v3 L=0.28U W=1U AS=0.5P AD=0.5P PS=3U PD=3U
M$43 \$60 MODIN \$15 VSS nfet_03v3 L=0.28U W=2U AS=1P AD=1P PS=5U PD=5U
M$44 \$5 \$59 VSS VSS nfet_03v3 L=0.28U W=1U AS=0.5P AD=0.5P PS=3U PD=3U
M$45 CKOUT \$58 VSS VSS nfet_03v3 L=0.28U W=2U AS=1P AD=1P PS=5U PD=5U
M$46 \$3 MODOUT VSS VSS nfet_03v3 L=0.28U W=3U AS=1.5P AD=1.5P PS=7U PD=7U
M$47 \$21 \$18 \$19 VSS nfet_03v3 L=0.28U W=1U AS=0.5P AD=0.5P PS=3U PD=3U
M$48 \$12 \$8 \$10 VSS nfet_03v3 L=0.28U W=1U AS=0.5P AD=0.5P PS=3U PD=3U
M$49 \$13 \$12 VSS VSS nfet_03v3 L=0.28U W=1U AS=0.5P AD=0.5P PS=3U PD=3U
M$50 \$18 \$17 VSS VSS nfet_03v3 L=0.28U W=1U AS=0.5P AD=0.5P PS=3U PD=3U
M$51 \$8 \$7 VSS VSS nfet_03v3 L=0.28U W=1U AS=0.5P AD=0.5P PS=3U PD=3U
M$52 \$11 \$10 VSS VSS nfet_03v3 L=0.28U W=1U AS=0.5P AD=0.5P PS=3U PD=3U
M$53 \$10 \$9 VSS VSS nfet_03v3 L=0.28U W=1U AS=0.5P AD=0.5P PS=3U PD=3U
M$54 \$12 \$7 \$58 VSS nfet_03v3 L=0.28U W=1U AS=0.5P AD=0.5P PS=3U PD=3U
M$55 \$58 \$13 VSS VSS nfet_03v3 L=0.28U W=1U AS=0.5P AD=0.5P PS=3U PD=3U
M$56 \$59 \$58 \$4 VSS nfet_03v3 L=0.28U W=2U AS=1P AD=1P PS=5U PD=5U
M$57 \$56 MODIN \$55 VSS nfet_03v3 L=0.28U W=3U AS=1.5P AD=1.5P PS=7U PD=7U
M$58 \$22 MODOUT VSS VSS nfet_03v3 L=0.28U W=1U AS=0.5P AD=0.5P PS=3U PD=3U
M$59 MODOUT \$21 VSS VSS nfet_03v3 L=0.28U W=1U AS=0.5P AD=0.5P PS=3U PD=3U
M$60 \$55 P \$3 VSS nfet_03v3 L=0.28U W=3U AS=1.5P AD=1.5P PS=7U PD=7U
.ENDS div23_cell
