* Extracted by KLayout with GF180MCU LVS runset on : 21/09/2026 15:17

.SUBCKT divider_chain VSS MA MO0 VCO MO1 MO2 DIVOUTB DIVOUT MI0 P0 VDD_DIV CK1
+ NMI0 T0 XM0_NMID MI1 P1 CK2 NMI1 XM1_NMID T1 MI2 P2 CK3 NMI2 T2 XM2_NMID
+ XMA_NM2 XMA_NM1 MB SEL0 SEL1 SEL2 XMNO_PMID XNR0_PMID XNR1_PMID XNR2_PMID MO3
+ MO4 MO5 XFRT_CKB XFRT_CKBB XFRT_NM XFRT_NMA XFRT_NMB XFRT_NS FB FBB CK4 NMI3
+ XM3_NMID CK5 NMI4 XM4_NMID CK6 XM5_NMID XMB_NM2 MI3 P3 T3 MI4 P4 T4 SEL5 P5
+ T5 XMB_NM1 SEL3 SEL4 XNR3_PMID XNR4_PMID
M$1 XMNO_PMID MB DIVOUTB VDD_DIV pfet_03v3 L=0.28U W=5U AS=2.5P AD=2.5P PS=11U
+ PD=11U
M$2 VDD_DIV DIVOUTB DIVOUT VDD_DIV pfet_03v3 L=0.28U W=5U AS=2.5P AD=2.5P
+ PS=11U PD=11U
M$3 VDD_DIV MI0 \$11 VDD_DIV pfet_03v3 L=0.28U W=2.5U AS=1.25P AD=1.25P PS=6U
+ PD=6U
M$4 VDD_DIV P0 \$11 VDD_DIV pfet_03v3 L=0.28U W=2.5U AS=1.25P AD=1.25P PS=6U
+ PD=6U
M$5 VDD_DIV MO0 \$11 VDD_DIV pfet_03v3 L=0.28U W=2.5U AS=1.25P AD=1.25P PS=6U
+ PD=6U
M$6 VDD_DIV \$15 \$16 VDD_DIV pfet_03v3 L=0.28U W=2.5U AS=1.25P AD=1.25P PS=6U
+ PD=6U
M$7 VDD_DIV \$11 \$16 VDD_DIV pfet_03v3 L=0.28U W=2.5U AS=1.25P AD=1.25P PS=6U
+ PD=6U
M$8 VDD_DIV \$16 \$18 VDD_DIV pfet_03v3 L=0.28U W=2.5U AS=1.25P AD=1.25P PS=6U
+ PD=6U
M$9 VDD_DIV VCO \$19 VDD_DIV pfet_03v3 L=0.28U W=2.5U AS=1.25P AD=1.25P PS=6U
+ PD=6U
M$10 VDD_DIV \$19 \$20 VDD_DIV pfet_03v3 L=0.28U W=2.5U AS=1.25P AD=1.25P PS=6U
+ PD=6U
M$11 \$18 \$20 \$21 VDD_DIV pfet_03v3 L=0.28U W=2.5U AS=1.25P AD=1.25P PS=6U
+ PD=6U
M$12 VDD_DIV \$21 \$22 VDD_DIV pfet_03v3 L=0.28U W=2.5U AS=1.25P AD=1.25P PS=6U
+ PD=6U
M$13 VDD_DIV \$22 \$23 VDD_DIV pfet_03v3 L=0.28U W=2.5U AS=1.25P AD=1.25P PS=6U
+ PD=6U
M$14 \$23 \$19 \$21 VDD_DIV pfet_03v3 L=0.28U W=2.5U AS=1.25P AD=1.25P PS=6U
+ PD=6U
M$15 \$22 \$19 \$24 VDD_DIV pfet_03v3 L=0.28U W=2.5U AS=1.25P AD=1.25P PS=6U
+ PD=6U
M$16 VDD_DIV \$24 \$25 VDD_DIV pfet_03v3 L=0.28U W=2.5U AS=1.25P AD=1.25P PS=6U
+ PD=6U
M$17 VDD_DIV \$25 \$15 VDD_DIV pfet_03v3 L=0.28U W=2.5U AS=1.25P AD=1.25P PS=6U
+ PD=6U
M$18 \$15 \$20 \$24 VDD_DIV pfet_03v3 L=0.28U W=2.5U AS=1.25P AD=1.25P PS=6U
+ PD=6U
M$19 VDD_DIV \$15 CK1 VDD_DIV pfet_03v3 L=0.28U W=5U AS=2.5P AD=2.5P PS=11U
+ PD=11U
M$20 VDD_DIV MI0 \$27 VDD_DIV pfet_03v3 L=0.28U W=2.5U AS=1.25P AD=1.25P PS=6U
+ PD=6U
M$21 VDD_DIV \$25 \$27 VDD_DIV pfet_03v3 L=0.28U W=2.5U AS=1.25P AD=1.25P PS=6U
+ PD=6U
M$22 VDD_DIV \$27 \$29 VDD_DIV pfet_03v3 L=0.28U W=2.5U AS=1.25P AD=1.25P PS=6U
+ PD=6U
M$23 VDD_DIV VCO \$30 VDD_DIV pfet_03v3 L=0.28U W=2.5U AS=1.25P AD=1.25P PS=6U
+ PD=6U
M$24 VDD_DIV \$30 \$31 VDD_DIV pfet_03v3 L=0.28U W=2.5U AS=1.25P AD=1.25P PS=6U
+ PD=6U
M$25 \$29 \$31 \$32 VDD_DIV pfet_03v3 L=0.28U W=2.5U AS=1.25P AD=1.25P PS=6U
+ PD=6U
M$26 VDD_DIV \$32 \$33 VDD_DIV pfet_03v3 L=0.28U W=2.5U AS=1.25P AD=1.25P PS=6U
+ PD=6U
M$27 VDD_DIV \$33 \$34 VDD_DIV pfet_03v3 L=0.28U W=2.5U AS=1.25P AD=1.25P PS=6U
+ PD=6U
M$28 \$34 \$30 \$32 VDD_DIV pfet_03v3 L=0.28U W=2.5U AS=1.25P AD=1.25P PS=6U
+ PD=6U
M$29 \$33 \$30 \$35 VDD_DIV pfet_03v3 L=0.28U W=2.5U AS=1.25P AD=1.25P PS=6U
+ PD=6U
M$30 VDD_DIV \$35 MO0 VDD_DIV pfet_03v3 L=0.28U W=2.5U AS=1.25P AD=1.25P PS=6U
+ PD=6U
M$31 VDD_DIV MO0 \$36 VDD_DIV pfet_03v3 L=0.28U W=2.5U AS=1.25P AD=1.25P PS=6U
+ PD=6U
M$32 \$36 \$31 \$35 VDD_DIV pfet_03v3 L=0.28U W=2.5U AS=1.25P AD=1.25P PS=6U
+ PD=6U
M$33 XNR0_PMID SEL0 NMI0 VDD_DIV pfet_03v3 L=0.28U W=5U AS=2.5P AD=2.5P PS=11U
+ PD=11U
M$34 VDD_DIV NMI0 MI0 VDD_DIV pfet_03v3 L=0.28U W=2.5U AS=1.25P AD=1.25P PS=6U
+ PD=6U
M$35 VDD_DIV CK1 T0 VDD_DIV pfet_03v3 L=0.28U W=2.5U AS=1.25P AD=1.25P PS=6U
+ PD=6U
M$36 VDD_DIV SEL0 T0 VDD_DIV pfet_03v3 L=0.28U W=2.5U AS=1.25P AD=1.25P PS=6U
+ PD=6U
M$37 VDD_DIV MI1 \$42 VDD_DIV pfet_03v3 L=0.28U W=2.5U AS=1.25P AD=1.25P PS=6U
+ PD=6U
M$38 VDD_DIV P1 \$42 VDD_DIV pfet_03v3 L=0.28U W=2.5U AS=1.25P AD=1.25P PS=6U
+ PD=6U
M$39 VDD_DIV MO1 \$42 VDD_DIV pfet_03v3 L=0.28U W=2.5U AS=1.25P AD=1.25P PS=6U
+ PD=6U
M$40 VDD_DIV \$45 \$47 VDD_DIV pfet_03v3 L=0.28U W=2.5U AS=1.25P AD=1.25P PS=6U
+ PD=6U
M$41 VDD_DIV \$42 \$47 VDD_DIV pfet_03v3 L=0.28U W=2.5U AS=1.25P AD=1.25P PS=6U
+ PD=6U
M$42 VDD_DIV \$47 \$48 VDD_DIV pfet_03v3 L=0.28U W=2.5U AS=1.25P AD=1.25P PS=6U
+ PD=6U
M$43 VDD_DIV CK1 \$49 VDD_DIV pfet_03v3 L=0.28U W=2.5U AS=1.25P AD=1.25P PS=6U
+ PD=6U
M$44 VDD_DIV \$49 \$50 VDD_DIV pfet_03v3 L=0.28U W=2.5U AS=1.25P AD=1.25P PS=6U
+ PD=6U
M$45 \$48 \$50 \$51 VDD_DIV pfet_03v3 L=0.28U W=2.5U AS=1.25P AD=1.25P PS=6U
+ PD=6U
M$46 VDD_DIV \$51 \$52 VDD_DIV pfet_03v3 L=0.28U W=2.5U AS=1.25P AD=1.25P PS=6U
+ PD=6U
M$47 VDD_DIV \$52 \$53 VDD_DIV pfet_03v3 L=0.28U W=2.5U AS=1.25P AD=1.25P PS=6U
+ PD=6U
M$48 \$53 \$49 \$51 VDD_DIV pfet_03v3 L=0.28U W=2.5U AS=1.25P AD=1.25P PS=6U
+ PD=6U
M$49 \$52 \$49 \$54 VDD_DIV pfet_03v3 L=0.28U W=2.5U AS=1.25P AD=1.25P PS=6U
+ PD=6U
M$50 VDD_DIV \$54 \$55 VDD_DIV pfet_03v3 L=0.28U W=2.5U AS=1.25P AD=1.25P PS=6U
+ PD=6U
M$51 VDD_DIV \$55 \$45 VDD_DIV pfet_03v3 L=0.28U W=2.5U AS=1.25P AD=1.25P PS=6U
+ PD=6U
M$52 \$45 \$50 \$54 VDD_DIV pfet_03v3 L=0.28U W=2.5U AS=1.25P AD=1.25P PS=6U
+ PD=6U
M$53 VDD_DIV \$45 CK2 VDD_DIV pfet_03v3 L=0.28U W=5U AS=2.5P AD=2.5P PS=11U
+ PD=11U
M$54 VDD_DIV MI1 \$57 VDD_DIV pfet_03v3 L=0.28U W=2.5U AS=1.25P AD=1.25P PS=6U
+ PD=6U
M$55 VDD_DIV \$55 \$57 VDD_DIV pfet_03v3 L=0.28U W=2.5U AS=1.25P AD=1.25P PS=6U
+ PD=6U
M$56 VDD_DIV \$57 \$59 VDD_DIV pfet_03v3 L=0.28U W=2.5U AS=1.25P AD=1.25P PS=6U
+ PD=6U
M$57 VDD_DIV CK1 \$60 VDD_DIV pfet_03v3 L=0.28U W=2.5U AS=1.25P AD=1.25P PS=6U
+ PD=6U
M$58 VDD_DIV \$60 \$61 VDD_DIV pfet_03v3 L=0.28U W=2.5U AS=1.25P AD=1.25P PS=6U
+ PD=6U
M$59 \$59 \$61 \$62 VDD_DIV pfet_03v3 L=0.28U W=2.5U AS=1.25P AD=1.25P PS=6U
+ PD=6U
M$60 VDD_DIV \$62 \$63 VDD_DIV pfet_03v3 L=0.28U W=2.5U AS=1.25P AD=1.25P PS=6U
+ PD=6U
M$61 VDD_DIV \$63 \$64 VDD_DIV pfet_03v3 L=0.28U W=2.5U AS=1.25P AD=1.25P PS=6U
+ PD=6U
M$62 \$64 \$60 \$62 VDD_DIV pfet_03v3 L=0.28U W=2.5U AS=1.25P AD=1.25P PS=6U
+ PD=6U
M$63 \$63 \$60 \$65 VDD_DIV pfet_03v3 L=0.28U W=2.5U AS=1.25P AD=1.25P PS=6U
+ PD=6U
M$64 VDD_DIV \$65 MO1 VDD_DIV pfet_03v3 L=0.28U W=2.5U AS=1.25P AD=1.25P PS=6U
+ PD=6U
M$65 VDD_DIV MO1 \$66 VDD_DIV pfet_03v3 L=0.28U W=2.5U AS=1.25P AD=1.25P PS=6U
+ PD=6U
M$66 \$66 \$61 \$65 VDD_DIV pfet_03v3 L=0.28U W=2.5U AS=1.25P AD=1.25P PS=6U
+ PD=6U
M$67 XNR1_PMID SEL1 NMI1 VDD_DIV pfet_03v3 L=0.28U W=5U AS=2.5P AD=2.5P PS=11U
+ PD=11U
M$68 VDD_DIV NMI1 MI1 VDD_DIV pfet_03v3 L=0.28U W=2.5U AS=1.25P AD=1.25P PS=6U
+ PD=6U
M$69 VDD_DIV CK2 T1 VDD_DIV pfet_03v3 L=0.28U W=2.5U AS=1.25P AD=1.25P PS=6U
+ PD=6U
M$70 VDD_DIV SEL1 T1 VDD_DIV pfet_03v3 L=0.28U W=2.5U AS=1.25P AD=1.25P PS=6U
+ PD=6U
M$71 VDD_DIV MI2 \$74 VDD_DIV pfet_03v3 L=0.28U W=2.5U AS=1.25P AD=1.25P PS=6U
+ PD=6U
M$72 VDD_DIV P2 \$74 VDD_DIV pfet_03v3 L=0.28U W=2.5U AS=1.25P AD=1.25P PS=6U
+ PD=6U
M$73 VDD_DIV MO2 \$74 VDD_DIV pfet_03v3 L=0.28U W=2.5U AS=1.25P AD=1.25P PS=6U
+ PD=6U
M$74 VDD_DIV \$75 \$77 VDD_DIV pfet_03v3 L=0.28U W=2.5U AS=1.25P AD=1.25P PS=6U
+ PD=6U
M$75 VDD_DIV \$74 \$77 VDD_DIV pfet_03v3 L=0.28U W=2.5U AS=1.25P AD=1.25P PS=6U
+ PD=6U
M$76 VDD_DIV \$77 \$78 VDD_DIV pfet_03v3 L=0.28U W=2.5U AS=1.25P AD=1.25P PS=6U
+ PD=6U
M$77 VDD_DIV CK2 \$79 VDD_DIV pfet_03v3 L=0.28U W=2.5U AS=1.25P AD=1.25P PS=6U
+ PD=6U
M$78 VDD_DIV \$79 \$80 VDD_DIV pfet_03v3 L=0.28U W=2.5U AS=1.25P AD=1.25P PS=6U
+ PD=6U
M$79 \$78 \$80 \$81 VDD_DIV pfet_03v3 L=0.28U W=2.5U AS=1.25P AD=1.25P PS=6U
+ PD=6U
M$80 VDD_DIV \$81 \$82 VDD_DIV pfet_03v3 L=0.28U W=2.5U AS=1.25P AD=1.25P PS=6U
+ PD=6U
M$81 VDD_DIV \$82 \$83 VDD_DIV pfet_03v3 L=0.28U W=2.5U AS=1.25P AD=1.25P PS=6U
+ PD=6U
M$82 \$83 \$79 \$81 VDD_DIV pfet_03v3 L=0.28U W=2.5U AS=1.25P AD=1.25P PS=6U
+ PD=6U
M$83 \$82 \$79 \$84 VDD_DIV pfet_03v3 L=0.28U W=2.5U AS=1.25P AD=1.25P PS=6U
+ PD=6U
M$84 VDD_DIV \$84 \$85 VDD_DIV pfet_03v3 L=0.28U W=2.5U AS=1.25P AD=1.25P PS=6U
+ PD=6U
M$85 VDD_DIV \$85 \$75 VDD_DIV pfet_03v3 L=0.28U W=2.5U AS=1.25P AD=1.25P PS=6U
+ PD=6U
M$86 \$75 \$80 \$84 VDD_DIV pfet_03v3 L=0.28U W=2.5U AS=1.25P AD=1.25P PS=6U
+ PD=6U
M$87 VDD_DIV \$75 CK3 VDD_DIV pfet_03v3 L=0.28U W=5U AS=2.5P AD=2.5P PS=11U
+ PD=11U
M$88 VDD_DIV MI2 \$87 VDD_DIV pfet_03v3 L=0.28U W=2.5U AS=1.25P AD=1.25P PS=6U
+ PD=6U
M$89 VDD_DIV \$85 \$87 VDD_DIV pfet_03v3 L=0.28U W=2.5U AS=1.25P AD=1.25P PS=6U
+ PD=6U
M$90 VDD_DIV \$87 \$89 VDD_DIV pfet_03v3 L=0.28U W=2.5U AS=1.25P AD=1.25P PS=6U
+ PD=6U
M$91 VDD_DIV CK2 \$90 VDD_DIV pfet_03v3 L=0.28U W=2.5U AS=1.25P AD=1.25P PS=6U
+ PD=6U
M$92 VDD_DIV \$90 \$91 VDD_DIV pfet_03v3 L=0.28U W=2.5U AS=1.25P AD=1.25P PS=6U
+ PD=6U
M$93 \$89 \$91 \$92 VDD_DIV pfet_03v3 L=0.28U W=2.5U AS=1.25P AD=1.25P PS=6U
+ PD=6U
M$94 VDD_DIV \$92 \$93 VDD_DIV pfet_03v3 L=0.28U W=2.5U AS=1.25P AD=1.25P PS=6U
+ PD=6U
M$95 VDD_DIV \$93 \$94 VDD_DIV pfet_03v3 L=0.28U W=2.5U AS=1.25P AD=1.25P PS=6U
+ PD=6U
M$96 \$94 \$90 \$92 VDD_DIV pfet_03v3 L=0.28U W=2.5U AS=1.25P AD=1.25P PS=6U
+ PD=6U
M$97 \$93 \$90 \$95 VDD_DIV pfet_03v3 L=0.28U W=2.5U AS=1.25P AD=1.25P PS=6U
+ PD=6U
M$98 VDD_DIV \$95 MO2 VDD_DIV pfet_03v3 L=0.28U W=2.5U AS=1.25P AD=1.25P PS=6U
+ PD=6U
M$99 VDD_DIV MO2 \$96 VDD_DIV pfet_03v3 L=0.28U W=2.5U AS=1.25P AD=1.25P PS=6U
+ PD=6U
M$100 \$96 \$91 \$95 VDD_DIV pfet_03v3 L=0.28U W=2.5U AS=1.25P AD=1.25P PS=6U
+ PD=6U
M$101 XNR2_PMID SEL2 NMI2 VDD_DIV pfet_03v3 L=0.28U W=5U AS=2.5P AD=2.5P PS=11U
+ PD=11U
M$102 VDD_DIV NMI2 MI2 VDD_DIV pfet_03v3 L=0.28U W=2.5U AS=1.25P AD=1.25P PS=6U
+ PD=6U
M$103 VDD_DIV CK3 T2 VDD_DIV pfet_03v3 L=0.28U W=2.5U AS=1.25P AD=1.25P PS=6U
+ PD=6U
M$104 VDD_DIV SEL2 T2 VDD_DIV pfet_03v3 L=0.28U W=2.5U AS=1.25P AD=1.25P PS=6U
+ PD=6U
M$105 VDD_DIV T0 MA VDD_DIV pfet_03v3 L=0.28U W=2.5U AS=1.25P AD=1.25P PS=6U
+ PD=6U
M$106 VDD_DIV T1 MA VDD_DIV pfet_03v3 L=0.28U W=2.5U AS=1.25P AD=1.25P PS=6U
+ PD=6U
M$107 VDD_DIV T2 MA VDD_DIV pfet_03v3 L=0.28U W=2.5U AS=1.25P AD=1.25P PS=6U
+ PD=6U
M$108 VDD_DIV MA XMNO_PMID VDD_DIV pfet_03v3 L=0.28U W=5U AS=2.5P AD=2.5P
+ PS=11U PD=11U
M$109 VDD_DIV MO1 XNR0_PMID VDD_DIV pfet_03v3 L=0.28U W=5U AS=2.5P AD=2.5P
+ PS=11U PD=11U
M$110 VDD_DIV MO2 XNR1_PMID VDD_DIV pfet_03v3 L=0.28U W=5U AS=2.5P AD=2.5P
+ PS=11U PD=11U
M$111 VDD_DIV MO3 XNR2_PMID VDD_DIV pfet_03v3 L=0.28U W=5U AS=2.5P AD=2.5P
+ PS=11U PD=11U
M$112 VDD_DIV VCO XFRT_CKB VDD_DIV pfet_03v3 L=0.28U W=2.5U AS=1.25P AD=1.25P
+ PS=6U PD=6U
M$113 VDD_DIV XFRT_CKB XFRT_CKBB VDD_DIV pfet_03v3 L=0.28U W=2.5U AS=1.25P
+ AD=1.25P PS=6U PD=6U
M$114 DIVOUT XFRT_CKBB XFRT_NM VDD_DIV pfet_03v3 L=0.28U W=2.5U AS=1.25P
+ AD=1.25P PS=6U PD=6U
M$115 VDD_DIV XFRT_NM XFRT_NMA VDD_DIV pfet_03v3 L=0.28U W=2.5U AS=1.25P
+ AD=1.25P PS=6U PD=6U
M$116 VDD_DIV XFRT_NMA XFRT_NMB VDD_DIV pfet_03v3 L=0.28U W=2.5U AS=1.25P
+ AD=1.25P PS=6U PD=6U
M$117 XFRT_NMB XFRT_CKB XFRT_NM VDD_DIV pfet_03v3 L=0.28U W=2.5U AS=1.25P
+ AD=1.25P PS=6U PD=6U
M$118 XFRT_NMA XFRT_CKB XFRT_NS VDD_DIV pfet_03v3 L=0.28U W=2.5U AS=1.25P
+ AD=1.25P PS=6U PD=6U
M$119 VDD_DIV XFRT_NS FB VDD_DIV pfet_03v3 L=0.28U W=2.5U AS=1.25P AD=1.25P
+ PS=6U PD=6U
M$120 VDD_DIV FB FBB VDD_DIV pfet_03v3 L=0.28U W=2.5U AS=1.25P AD=1.25P PS=6U
+ PD=6U
M$121 FBB XFRT_CKBB XFRT_NS VDD_DIV pfet_03v3 L=0.28U W=2.5U AS=1.25P AD=1.25P
+ PS=6U PD=6U
M$122 VDD_DIV MI3 \$853 VDD_DIV pfet_03v3 L=0.28U W=2.5U AS=1.25P AD=1.25P
+ PS=6U PD=6U
M$123 VDD_DIV P3 \$853 VDD_DIV pfet_03v3 L=0.28U W=2.5U AS=1.25P AD=1.25P PS=6U
+ PD=6U
M$124 VDD_DIV MO3 \$853 VDD_DIV pfet_03v3 L=0.28U W=2.5U AS=1.25P AD=1.25P
+ PS=6U PD=6U
M$125 VDD_DIV \$855 \$856 VDD_DIV pfet_03v3 L=0.28U W=2.5U AS=1.25P AD=1.25P
+ PS=6U PD=6U
M$126 VDD_DIV \$853 \$856 VDD_DIV pfet_03v3 L=0.28U W=2.5U AS=1.25P AD=1.25P
+ PS=6U PD=6U
M$127 VDD_DIV \$856 \$574 VDD_DIV pfet_03v3 L=0.28U W=2.5U AS=1.25P AD=1.25P
+ PS=6U PD=6U
M$128 VDD_DIV CK3 \$575 VDD_DIV pfet_03v3 L=0.28U W=2.5U AS=1.25P AD=1.25P
+ PS=6U PD=6U
M$129 VDD_DIV \$575 \$576 VDD_DIV pfet_03v3 L=0.28U W=2.5U AS=1.25P AD=1.25P
+ PS=6U PD=6U
M$130 \$574 \$576 \$577 VDD_DIV pfet_03v3 L=0.28U W=2.5U AS=1.25P AD=1.25P
+ PS=6U PD=6U
M$131 VDD_DIV \$577 \$578 VDD_DIV pfet_03v3 L=0.28U W=2.5U AS=1.25P AD=1.25P
+ PS=6U PD=6U
M$132 VDD_DIV \$578 \$579 VDD_DIV pfet_03v3 L=0.28U W=2.5U AS=1.25P AD=1.25P
+ PS=6U PD=6U
M$133 \$579 \$575 \$577 VDD_DIV pfet_03v3 L=0.28U W=2.5U AS=1.25P AD=1.25P
+ PS=6U PD=6U
M$134 \$578 \$575 \$580 VDD_DIV pfet_03v3 L=0.28U W=2.5U AS=1.25P AD=1.25P
+ PS=6U PD=6U
M$135 VDD_DIV \$580 \$581 VDD_DIV pfet_03v3 L=0.28U W=2.5U AS=1.25P AD=1.25P
+ PS=6U PD=6U
M$136 VDD_DIV \$581 \$855 VDD_DIV pfet_03v3 L=0.28U W=2.5U AS=1.25P AD=1.25P
+ PS=6U PD=6U
M$137 \$855 \$576 \$580 VDD_DIV pfet_03v3 L=0.28U W=2.5U AS=1.25P AD=1.25P
+ PS=6U PD=6U
M$138 VDD_DIV \$855 CK4 VDD_DIV pfet_03v3 L=0.28U W=5U AS=2.5P AD=2.5P PS=11U
+ PD=11U
M$139 VDD_DIV MI3 \$857 VDD_DIV pfet_03v3 L=0.28U W=2.5U AS=1.25P AD=1.25P
+ PS=6U PD=6U
M$140 VDD_DIV \$581 \$857 VDD_DIV pfet_03v3 L=0.28U W=2.5U AS=1.25P AD=1.25P
+ PS=6U PD=6U
M$141 VDD_DIV \$857 \$584 VDD_DIV pfet_03v3 L=0.28U W=2.5U AS=1.25P AD=1.25P
+ PS=6U PD=6U
M$142 VDD_DIV CK3 \$585 VDD_DIV pfet_03v3 L=0.28U W=2.5U AS=1.25P AD=1.25P
+ PS=6U PD=6U
M$143 VDD_DIV \$585 \$586 VDD_DIV pfet_03v3 L=0.28U W=2.5U AS=1.25P AD=1.25P
+ PS=6U PD=6U
M$144 \$584 \$586 \$587 VDD_DIV pfet_03v3 L=0.28U W=2.5U AS=1.25P AD=1.25P
+ PS=6U PD=6U
M$145 VDD_DIV \$587 \$588 VDD_DIV pfet_03v3 L=0.28U W=2.5U AS=1.25P AD=1.25P
+ PS=6U PD=6U
M$146 VDD_DIV \$588 \$589 VDD_DIV pfet_03v3 L=0.28U W=2.5U AS=1.25P AD=1.25P
+ PS=6U PD=6U
M$147 \$589 \$585 \$587 VDD_DIV pfet_03v3 L=0.28U W=2.5U AS=1.25P AD=1.25P
+ PS=6U PD=6U
M$148 \$588 \$585 \$590 VDD_DIV pfet_03v3 L=0.28U W=2.5U AS=1.25P AD=1.25P
+ PS=6U PD=6U
M$149 VDD_DIV \$590 MO3 VDD_DIV pfet_03v3 L=0.28U W=2.5U AS=1.25P AD=1.25P
+ PS=6U PD=6U
M$150 VDD_DIV MO3 \$591 VDD_DIV pfet_03v3 L=0.28U W=2.5U AS=1.25P AD=1.25P
+ PS=6U PD=6U
M$151 \$591 \$586 \$590 VDD_DIV pfet_03v3 L=0.28U W=2.5U AS=1.25P AD=1.25P
+ PS=6U PD=6U
M$152 XNR3_PMID SEL3 NMI3 VDD_DIV pfet_03v3 L=0.28U W=5U AS=2.5P AD=2.5P PS=11U
+ PD=11U
M$153 VDD_DIV NMI3 MI3 VDD_DIV pfet_03v3 L=0.28U W=2.5U AS=1.25P AD=1.25P PS=6U
+ PD=6U
M$154 VDD_DIV CK4 T3 VDD_DIV pfet_03v3 L=0.28U W=2.5U AS=1.25P AD=1.25P PS=6U
+ PD=6U
M$155 VDD_DIV SEL3 T3 VDD_DIV pfet_03v3 L=0.28U W=2.5U AS=1.25P AD=1.25P PS=6U
+ PD=6U
M$156 VDD_DIV MI4 \$862 VDD_DIV pfet_03v3 L=0.28U W=2.5U AS=1.25P AD=1.25P
+ PS=6U PD=6U
M$157 VDD_DIV P4 \$862 VDD_DIV pfet_03v3 L=0.28U W=2.5U AS=1.25P AD=1.25P PS=6U
+ PD=6U
M$158 VDD_DIV MO4 \$862 VDD_DIV pfet_03v3 L=0.28U W=2.5U AS=1.25P AD=1.25P
+ PS=6U PD=6U
M$159 VDD_DIV \$863 \$864 VDD_DIV pfet_03v3 L=0.28U W=2.5U AS=1.25P AD=1.25P
+ PS=6U PD=6U
M$160 VDD_DIV \$862 \$864 VDD_DIV pfet_03v3 L=0.28U W=2.5U AS=1.25P AD=1.25P
+ PS=6U PD=6U
M$161 VDD_DIV \$864 \$596 VDD_DIV pfet_03v3 L=0.28U W=2.5U AS=1.25P AD=1.25P
+ PS=6U PD=6U
M$162 VDD_DIV CK4 \$597 VDD_DIV pfet_03v3 L=0.28U W=2.5U AS=1.25P AD=1.25P
+ PS=6U PD=6U
M$163 VDD_DIV \$597 \$598 VDD_DIV pfet_03v3 L=0.28U W=2.5U AS=1.25P AD=1.25P
+ PS=6U PD=6U
M$164 \$596 \$598 \$599 VDD_DIV pfet_03v3 L=0.28U W=2.5U AS=1.25P AD=1.25P
+ PS=6U PD=6U
M$165 VDD_DIV \$599 \$600 VDD_DIV pfet_03v3 L=0.28U W=2.5U AS=1.25P AD=1.25P
+ PS=6U PD=6U
M$166 VDD_DIV \$600 \$601 VDD_DIV pfet_03v3 L=0.28U W=2.5U AS=1.25P AD=1.25P
+ PS=6U PD=6U
M$167 \$601 \$597 \$599 VDD_DIV pfet_03v3 L=0.28U W=2.5U AS=1.25P AD=1.25P
+ PS=6U PD=6U
M$168 \$600 \$597 \$602 VDD_DIV pfet_03v3 L=0.28U W=2.5U AS=1.25P AD=1.25P
+ PS=6U PD=6U
M$169 VDD_DIV \$602 \$603 VDD_DIV pfet_03v3 L=0.28U W=2.5U AS=1.25P AD=1.25P
+ PS=6U PD=6U
M$170 VDD_DIV \$603 \$863 VDD_DIV pfet_03v3 L=0.28U W=2.5U AS=1.25P AD=1.25P
+ PS=6U PD=6U
M$171 \$863 \$598 \$602 VDD_DIV pfet_03v3 L=0.28U W=2.5U AS=1.25P AD=1.25P
+ PS=6U PD=6U
M$172 VDD_DIV \$863 CK5 VDD_DIV pfet_03v3 L=0.28U W=5U AS=2.5P AD=2.5P PS=11U
+ PD=11U
M$173 VDD_DIV MI4 \$865 VDD_DIV pfet_03v3 L=0.28U W=2.5U AS=1.25P AD=1.25P
+ PS=6U PD=6U
M$174 VDD_DIV \$603 \$865 VDD_DIV pfet_03v3 L=0.28U W=2.5U AS=1.25P AD=1.25P
+ PS=6U PD=6U
M$175 VDD_DIV \$865 \$606 VDD_DIV pfet_03v3 L=0.28U W=2.5U AS=1.25P AD=1.25P
+ PS=6U PD=6U
M$176 VDD_DIV CK4 \$607 VDD_DIV pfet_03v3 L=0.28U W=2.5U AS=1.25P AD=1.25P
+ PS=6U PD=6U
M$177 VDD_DIV \$607 \$608 VDD_DIV pfet_03v3 L=0.28U W=2.5U AS=1.25P AD=1.25P
+ PS=6U PD=6U
M$178 \$606 \$608 \$609 VDD_DIV pfet_03v3 L=0.28U W=2.5U AS=1.25P AD=1.25P
+ PS=6U PD=6U
M$179 VDD_DIV \$609 \$610 VDD_DIV pfet_03v3 L=0.28U W=2.5U AS=1.25P AD=1.25P
+ PS=6U PD=6U
M$180 VDD_DIV \$610 \$611 VDD_DIV pfet_03v3 L=0.28U W=2.5U AS=1.25P AD=1.25P
+ PS=6U PD=6U
M$181 \$611 \$607 \$609 VDD_DIV pfet_03v3 L=0.28U W=2.5U AS=1.25P AD=1.25P
+ PS=6U PD=6U
M$182 \$610 \$607 \$612 VDD_DIV pfet_03v3 L=0.28U W=2.5U AS=1.25P AD=1.25P
+ PS=6U PD=6U
M$183 VDD_DIV \$612 MO4 VDD_DIV pfet_03v3 L=0.28U W=2.5U AS=1.25P AD=1.25P
+ PS=6U PD=6U
M$184 VDD_DIV MO4 \$613 VDD_DIV pfet_03v3 L=0.28U W=2.5U AS=1.25P AD=1.25P
+ PS=6U PD=6U
M$185 \$613 \$608 \$612 VDD_DIV pfet_03v3 L=0.28U W=2.5U AS=1.25P AD=1.25P
+ PS=6U PD=6U
M$186 XNR4_PMID SEL4 NMI4 VDD_DIV pfet_03v3 L=0.28U W=5U AS=2.5P AD=2.5P PS=11U
+ PD=11U
M$187 VDD_DIV NMI4 MI4 VDD_DIV pfet_03v3 L=0.28U W=2.5U AS=1.25P AD=1.25P PS=6U
+ PD=6U
M$188 VDD_DIV CK5 T4 VDD_DIV pfet_03v3 L=0.28U W=2.5U AS=1.25P AD=1.25P PS=6U
+ PD=6U
M$189 VDD_DIV SEL4 T4 VDD_DIV pfet_03v3 L=0.28U W=2.5U AS=1.25P AD=1.25P PS=6U
+ PD=6U
M$190 VDD_DIV SEL5 \$869 VDD_DIV pfet_03v3 L=0.28U W=2.5U AS=1.25P AD=1.25P
+ PS=6U PD=6U
M$191 VDD_DIV P5 \$869 VDD_DIV pfet_03v3 L=0.28U W=2.5U AS=1.25P AD=1.25P PS=6U
+ PD=6U
M$192 VDD_DIV MO5 \$869 VDD_DIV pfet_03v3 L=0.28U W=2.5U AS=1.25P AD=1.25P
+ PS=6U PD=6U
M$193 VDD_DIV \$871 \$872 VDD_DIV pfet_03v3 L=0.28U W=2.5U AS=1.25P AD=1.25P
+ PS=6U PD=6U
M$194 VDD_DIV \$869 \$872 VDD_DIV pfet_03v3 L=0.28U W=2.5U AS=1.25P AD=1.25P
+ PS=6U PD=6U
M$195 VDD_DIV \$872 \$618 VDD_DIV pfet_03v3 L=0.28U W=2.5U AS=1.25P AD=1.25P
+ PS=6U PD=6U
M$196 VDD_DIV CK5 \$619 VDD_DIV pfet_03v3 L=0.28U W=2.5U AS=1.25P AD=1.25P
+ PS=6U PD=6U
M$197 VDD_DIV \$619 \$620 VDD_DIV pfet_03v3 L=0.28U W=2.5U AS=1.25P AD=1.25P
+ PS=6U PD=6U
M$198 \$618 \$620 \$621 VDD_DIV pfet_03v3 L=0.28U W=2.5U AS=1.25P AD=1.25P
+ PS=6U PD=6U
M$199 VDD_DIV \$621 \$622 VDD_DIV pfet_03v3 L=0.28U W=2.5U AS=1.25P AD=1.25P
+ PS=6U PD=6U
M$200 VDD_DIV \$622 \$623 VDD_DIV pfet_03v3 L=0.28U W=2.5U AS=1.25P AD=1.25P
+ PS=6U PD=6U
M$201 \$623 \$619 \$621 VDD_DIV pfet_03v3 L=0.28U W=2.5U AS=1.25P AD=1.25P
+ PS=6U PD=6U
M$202 \$622 \$619 \$624 VDD_DIV pfet_03v3 L=0.28U W=2.5U AS=1.25P AD=1.25P
+ PS=6U PD=6U
M$203 VDD_DIV \$624 \$625 VDD_DIV pfet_03v3 L=0.28U W=2.5U AS=1.25P AD=1.25P
+ PS=6U PD=6U
M$204 VDD_DIV \$625 \$871 VDD_DIV pfet_03v3 L=0.28U W=2.5U AS=1.25P AD=1.25P
+ PS=6U PD=6U
M$205 \$871 \$620 \$624 VDD_DIV pfet_03v3 L=0.28U W=2.5U AS=1.25P AD=1.25P
+ PS=6U PD=6U
M$206 VDD_DIV \$871 CK6 VDD_DIV pfet_03v3 L=0.28U W=5U AS=2.5P AD=2.5P PS=11U
+ PD=11U
M$207 VDD_DIV SEL5 \$873 VDD_DIV pfet_03v3 L=0.28U W=2.5U AS=1.25P AD=1.25P
+ PS=6U PD=6U
M$208 VDD_DIV \$625 \$873 VDD_DIV pfet_03v3 L=0.28U W=2.5U AS=1.25P AD=1.25P
+ PS=6U PD=6U
M$209 VDD_DIV \$873 \$628 VDD_DIV pfet_03v3 L=0.28U W=2.5U AS=1.25P AD=1.25P
+ PS=6U PD=6U
M$210 VDD_DIV CK5 \$629 VDD_DIV pfet_03v3 L=0.28U W=2.5U AS=1.25P AD=1.25P
+ PS=6U PD=6U
M$211 VDD_DIV \$629 \$630 VDD_DIV pfet_03v3 L=0.28U W=2.5U AS=1.25P AD=1.25P
+ PS=6U PD=6U
M$212 \$628 \$630 \$631 VDD_DIV pfet_03v3 L=0.28U W=2.5U AS=1.25P AD=1.25P
+ PS=6U PD=6U
M$213 VDD_DIV \$631 \$632 VDD_DIV pfet_03v3 L=0.28U W=2.5U AS=1.25P AD=1.25P
+ PS=6U PD=6U
M$214 VDD_DIV \$632 \$633 VDD_DIV pfet_03v3 L=0.28U W=2.5U AS=1.25P AD=1.25P
+ PS=6U PD=6U
M$215 \$633 \$629 \$631 VDD_DIV pfet_03v3 L=0.28U W=2.5U AS=1.25P AD=1.25P
+ PS=6U PD=6U
M$216 \$632 \$629 \$634 VDD_DIV pfet_03v3 L=0.28U W=2.5U AS=1.25P AD=1.25P
+ PS=6U PD=6U
M$217 VDD_DIV \$634 MO5 VDD_DIV pfet_03v3 L=0.28U W=2.5U AS=1.25P AD=1.25P
+ PS=6U PD=6U
M$218 VDD_DIV MO5 \$635 VDD_DIV pfet_03v3 L=0.28U W=2.5U AS=1.25P AD=1.25P
+ PS=6U PD=6U
M$219 \$635 \$630 \$634 VDD_DIV pfet_03v3 L=0.28U W=2.5U AS=1.25P AD=1.25P
+ PS=6U PD=6U
M$220 VDD_DIV CK6 T5 VDD_DIV pfet_03v3 L=0.28U W=2.5U AS=1.25P AD=1.25P PS=6U
+ PD=6U
M$221 VDD_DIV SEL5 T5 VDD_DIV pfet_03v3 L=0.28U W=2.5U AS=1.25P AD=1.25P PS=6U
+ PD=6U
M$222 VDD_DIV T3 MB VDD_DIV pfet_03v3 L=0.28U W=2.5U AS=1.25P AD=1.25P PS=6U
+ PD=6U
M$223 VDD_DIV T4 MB VDD_DIV pfet_03v3 L=0.28U W=2.5U AS=1.25P AD=1.25P PS=6U
+ PD=6U
M$224 VDD_DIV T5 MB VDD_DIV pfet_03v3 L=0.28U W=2.5U AS=1.25P AD=1.25P PS=6U
+ PD=6U
M$225 VDD_DIV MO4 XNR3_PMID VDD_DIV pfet_03v3 L=0.28U W=5U AS=2.5P AD=2.5P
+ PS=11U PD=11U
M$226 VDD_DIV MO5 XNR4_PMID VDD_DIV pfet_03v3 L=0.28U W=5U AS=2.5P AD=2.5P
+ PS=11U PD=11U
M$227 DIVOUTB MA VSS VSS nfet_03v3 L=0.28U W=1U AS=0.5P AD=0.5P PS=3U PD=3U
M$228 DIVOUTB MB VSS VSS nfet_03v3 L=0.28U W=1U AS=0.5P AD=0.5P PS=3U PD=3U
M$229 DIVOUT DIVOUTB VSS VSS nfet_03v3 L=0.28U W=2U AS=1P AD=1P PS=5U PD=5U
M$230 \$12 MO0 VSS VSS nfet_03v3 L=0.28U W=3U AS=1.5P AD=1.5P PS=7U PD=7U
M$231 \$17 \$11 VSS VSS nfet_03v3 L=0.28U W=2U AS=1P AD=1P PS=5U PD=5U
M$232 \$18 \$16 VSS VSS nfet_03v3 L=0.28U W=1U AS=0.5P AD=0.5P PS=3U PD=3U
M$233 \$19 VCO VSS VSS nfet_03v3 L=0.28U W=1U AS=0.5P AD=0.5P PS=3U PD=3U
M$234 \$20 \$19 VSS VSS nfet_03v3 L=0.28U W=1U AS=0.5P AD=0.5P PS=3U PD=3U
M$235 \$21 \$19 \$18 VSS nfet_03v3 L=0.28U W=1U AS=0.5P AD=0.5P PS=3U PD=3U
M$236 \$22 \$21 VSS VSS nfet_03v3 L=0.28U W=1U AS=0.5P AD=0.5P PS=3U PD=3U
M$237 \$23 \$22 VSS VSS nfet_03v3 L=0.28U W=1U AS=0.5P AD=0.5P PS=3U PD=3U
M$238 \$21 \$20 \$23 VSS nfet_03v3 L=0.28U W=1U AS=0.5P AD=0.5P PS=3U PD=3U
M$239 \$24 \$20 \$22 VSS nfet_03v3 L=0.28U W=1U AS=0.5P AD=0.5P PS=3U PD=3U
M$240 \$25 \$24 VSS VSS nfet_03v3 L=0.28U W=1U AS=0.5P AD=0.5P PS=3U PD=3U
M$241 \$15 \$25 VSS VSS nfet_03v3 L=0.28U W=1U AS=0.5P AD=0.5P PS=3U PD=3U
M$242 \$24 \$19 \$15 VSS nfet_03v3 L=0.28U W=1U AS=0.5P AD=0.5P PS=3U PD=3U
M$243 CK1 \$15 VSS VSS nfet_03v3 L=0.28U W=2U AS=1P AD=1P PS=5U PD=5U
M$244 \$28 \$25 VSS VSS nfet_03v3 L=0.28U W=2U AS=1P AD=1P PS=5U PD=5U
M$245 \$29 \$27 VSS VSS nfet_03v3 L=0.28U W=1U AS=0.5P AD=0.5P PS=3U PD=3U
M$246 \$30 VCO VSS VSS nfet_03v3 L=0.28U W=1U AS=0.5P AD=0.5P PS=3U PD=3U
M$247 \$31 \$30 VSS VSS nfet_03v3 L=0.28U W=1U AS=0.5P AD=0.5P PS=3U PD=3U
M$248 \$32 \$30 \$29 VSS nfet_03v3 L=0.28U W=1U AS=0.5P AD=0.5P PS=3U PD=3U
M$249 \$33 \$32 VSS VSS nfet_03v3 L=0.28U W=1U AS=0.5P AD=0.5P PS=3U PD=3U
M$250 \$34 \$33 VSS VSS nfet_03v3 L=0.28U W=1U AS=0.5P AD=0.5P PS=3U PD=3U
M$251 \$32 \$31 \$34 VSS nfet_03v3 L=0.28U W=1U AS=0.5P AD=0.5P PS=3U PD=3U
M$252 \$35 \$31 \$33 VSS nfet_03v3 L=0.28U W=1U AS=0.5P AD=0.5P PS=3U PD=3U
M$253 MO0 \$35 VSS VSS nfet_03v3 L=0.28U W=1U AS=0.5P AD=0.5P PS=3U PD=3U
M$254 \$36 MO0 VSS VSS nfet_03v3 L=0.28U W=1U AS=0.5P AD=0.5P PS=3U PD=3U
M$255 \$35 \$30 \$36 VSS nfet_03v3 L=0.28U W=1U AS=0.5P AD=0.5P PS=3U PD=3U
M$256 NMI0 MO1 VSS VSS nfet_03v3 L=0.28U W=1U AS=0.5P AD=0.5P PS=3U PD=3U
M$257 NMI0 SEL0 VSS VSS nfet_03v3 L=0.28U W=1U AS=0.5P AD=0.5P PS=3U PD=3U
M$258 MI0 NMI0 VSS VSS nfet_03v3 L=0.28U W=1U AS=0.5P AD=0.5P PS=3U PD=3U
M$259 XM0_NMID SEL0 VSS VSS nfet_03v3 L=0.28U W=2U AS=1P AD=1P PS=5U PD=5U
M$260 \$44 MO1 VSS VSS nfet_03v3 L=0.28U W=3U AS=1.5P AD=1.5P PS=7U PD=7U
M$261 \$46 \$42 VSS VSS nfet_03v3 L=0.28U W=2U AS=1P AD=1P PS=5U PD=5U
M$262 \$48 \$47 VSS VSS nfet_03v3 L=0.28U W=1U AS=0.5P AD=0.5P PS=3U PD=3U
M$263 \$49 CK1 VSS VSS nfet_03v3 L=0.28U W=1U AS=0.5P AD=0.5P PS=3U PD=3U
M$264 \$50 \$49 VSS VSS nfet_03v3 L=0.28U W=1U AS=0.5P AD=0.5P PS=3U PD=3U
M$265 \$51 \$49 \$48 VSS nfet_03v3 L=0.28U W=1U AS=0.5P AD=0.5P PS=3U PD=3U
M$266 \$52 \$51 VSS VSS nfet_03v3 L=0.28U W=1U AS=0.5P AD=0.5P PS=3U PD=3U
M$267 \$53 \$52 VSS VSS nfet_03v3 L=0.28U W=1U AS=0.5P AD=0.5P PS=3U PD=3U
M$268 \$51 \$50 \$53 VSS nfet_03v3 L=0.28U W=1U AS=0.5P AD=0.5P PS=3U PD=3U
M$269 \$54 \$50 \$52 VSS nfet_03v3 L=0.28U W=1U AS=0.5P AD=0.5P PS=3U PD=3U
M$270 \$55 \$54 VSS VSS nfet_03v3 L=0.28U W=1U AS=0.5P AD=0.5P PS=3U PD=3U
M$271 \$45 \$55 VSS VSS nfet_03v3 L=0.28U W=1U AS=0.5P AD=0.5P PS=3U PD=3U
M$272 \$54 \$49 \$45 VSS nfet_03v3 L=0.28U W=1U AS=0.5P AD=0.5P PS=3U PD=3U
M$273 CK2 \$45 VSS VSS nfet_03v3 L=0.28U W=2U AS=1P AD=1P PS=5U PD=5U
M$274 \$58 \$55 VSS VSS nfet_03v3 L=0.28U W=2U AS=1P AD=1P PS=5U PD=5U
M$275 \$59 \$57 VSS VSS nfet_03v3 L=0.28U W=1U AS=0.5P AD=0.5P PS=3U PD=3U
M$276 \$60 CK1 VSS VSS nfet_03v3 L=0.28U W=1U AS=0.5P AD=0.5P PS=3U PD=3U
M$277 \$61 \$60 VSS VSS nfet_03v3 L=0.28U W=1U AS=0.5P AD=0.5P PS=3U PD=3U
M$278 \$62 \$60 \$59 VSS nfet_03v3 L=0.28U W=1U AS=0.5P AD=0.5P PS=3U PD=3U
M$279 \$63 \$62 VSS VSS nfet_03v3 L=0.28U W=1U AS=0.5P AD=0.5P PS=3U PD=3U
M$280 \$64 \$63 VSS VSS nfet_03v3 L=0.28U W=1U AS=0.5P AD=0.5P PS=3U PD=3U
M$281 \$62 \$61 \$64 VSS nfet_03v3 L=0.28U W=1U AS=0.5P AD=0.5P PS=3U PD=3U
M$282 \$65 \$61 \$63 VSS nfet_03v3 L=0.28U W=1U AS=0.5P AD=0.5P PS=3U PD=3U
M$283 MO1 \$65 VSS VSS nfet_03v3 L=0.28U W=1U AS=0.5P AD=0.5P PS=3U PD=3U
M$284 \$66 MO1 VSS VSS nfet_03v3 L=0.28U W=1U AS=0.5P AD=0.5P PS=3U PD=3U
M$285 \$65 \$60 \$66 VSS nfet_03v3 L=0.28U W=1U AS=0.5P AD=0.5P PS=3U PD=3U
M$286 NMI1 MO2 VSS VSS nfet_03v3 L=0.28U W=1U AS=0.5P AD=0.5P PS=3U PD=3U
M$287 NMI1 SEL1 VSS VSS nfet_03v3 L=0.28U W=1U AS=0.5P AD=0.5P PS=3U PD=3U
M$288 MI1 NMI1 VSS VSS nfet_03v3 L=0.28U W=1U AS=0.5P AD=0.5P PS=3U PD=3U
M$289 XM1_NMID SEL1 VSS VSS nfet_03v3 L=0.28U W=2U AS=1P AD=1P PS=5U PD=5U
M$290 \$73 MO2 VSS VSS nfet_03v3 L=0.28U W=3U AS=1.5P AD=1.5P PS=7U PD=7U
M$291 \$76 \$74 VSS VSS nfet_03v3 L=0.28U W=2U AS=1P AD=1P PS=5U PD=5U
M$292 \$78 \$77 VSS VSS nfet_03v3 L=0.28U W=1U AS=0.5P AD=0.5P PS=3U PD=3U
M$293 \$79 CK2 VSS VSS nfet_03v3 L=0.28U W=1U AS=0.5P AD=0.5P PS=3U PD=3U
M$294 \$80 \$79 VSS VSS nfet_03v3 L=0.28U W=1U AS=0.5P AD=0.5P PS=3U PD=3U
M$295 \$81 \$79 \$78 VSS nfet_03v3 L=0.28U W=1U AS=0.5P AD=0.5P PS=3U PD=3U
M$296 \$82 \$81 VSS VSS nfet_03v3 L=0.28U W=1U AS=0.5P AD=0.5P PS=3U PD=3U
M$297 \$83 \$82 VSS VSS nfet_03v3 L=0.28U W=1U AS=0.5P AD=0.5P PS=3U PD=3U
M$298 \$81 \$80 \$83 VSS nfet_03v3 L=0.28U W=1U AS=0.5P AD=0.5P PS=3U PD=3U
M$299 \$84 \$80 \$82 VSS nfet_03v3 L=0.28U W=1U AS=0.5P AD=0.5P PS=3U PD=3U
M$300 \$85 \$84 VSS VSS nfet_03v3 L=0.28U W=1U AS=0.5P AD=0.5P PS=3U PD=3U
M$301 \$75 \$85 VSS VSS nfet_03v3 L=0.28U W=1U AS=0.5P AD=0.5P PS=3U PD=3U
M$302 \$84 \$79 \$75 VSS nfet_03v3 L=0.28U W=1U AS=0.5P AD=0.5P PS=3U PD=3U
M$303 CK3 \$75 VSS VSS nfet_03v3 L=0.28U W=2U AS=1P AD=1P PS=5U PD=5U
M$304 \$88 \$85 VSS VSS nfet_03v3 L=0.28U W=2U AS=1P AD=1P PS=5U PD=5U
M$305 \$89 \$87 VSS VSS nfet_03v3 L=0.28U W=1U AS=0.5P AD=0.5P PS=3U PD=3U
M$306 \$90 CK2 VSS VSS nfet_03v3 L=0.28U W=1U AS=0.5P AD=0.5P PS=3U PD=3U
M$307 \$91 \$90 VSS VSS nfet_03v3 L=0.28U W=1U AS=0.5P AD=0.5P PS=3U PD=3U
M$308 \$92 \$90 \$89 VSS nfet_03v3 L=0.28U W=1U AS=0.5P AD=0.5P PS=3U PD=3U
M$309 \$93 \$92 VSS VSS nfet_03v3 L=0.28U W=1U AS=0.5P AD=0.5P PS=3U PD=3U
M$310 \$94 \$93 VSS VSS nfet_03v3 L=0.28U W=1U AS=0.5P AD=0.5P PS=3U PD=3U
M$311 \$92 \$91 \$94 VSS nfet_03v3 L=0.28U W=1U AS=0.5P AD=0.5P PS=3U PD=3U
M$312 \$95 \$91 \$93 VSS nfet_03v3 L=0.28U W=1U AS=0.5P AD=0.5P PS=3U PD=3U
M$313 MO2 \$95 VSS VSS nfet_03v3 L=0.28U W=1U AS=0.5P AD=0.5P PS=3U PD=3U
M$314 \$96 MO2 VSS VSS nfet_03v3 L=0.28U W=1U AS=0.5P AD=0.5P PS=3U PD=3U
M$315 \$95 \$90 \$96 VSS nfet_03v3 L=0.28U W=1U AS=0.5P AD=0.5P PS=3U PD=3U
M$316 NMI2 MO3 VSS VSS nfet_03v3 L=0.28U W=1U AS=0.5P AD=0.5P PS=3U PD=3U
M$317 NMI2 SEL2 VSS VSS nfet_03v3 L=0.28U W=1U AS=0.5P AD=0.5P PS=3U PD=3U
M$318 MI2 NMI2 VSS VSS nfet_03v3 L=0.28U W=1U AS=0.5P AD=0.5P PS=3U PD=3U
M$319 XM2_NMID SEL2 VSS VSS nfet_03v3 L=0.28U W=2U AS=1P AD=1P PS=5U PD=5U
M$320 XMA_NM2 T2 VSS VSS nfet_03v3 L=0.28U W=3U AS=1.5P AD=1.5P PS=7U PD=7U
M$321 \$13 P0 \$12 VSS nfet_03v3 L=0.28U W=3U AS=1.5P AD=1.5P PS=7U PD=7U
M$322 \$11 MI0 \$13 VSS nfet_03v3 L=0.28U W=3U AS=1.5P AD=1.5P PS=7U PD=7U
M$323 \$16 \$15 \$17 VSS nfet_03v3 L=0.28U W=2U AS=1P AD=1P PS=5U PD=5U
M$324 \$27 MI0 \$28 VSS nfet_03v3 L=0.28U W=2U AS=1P AD=1P PS=5U PD=5U
M$325 T0 CK1 XM0_NMID VSS nfet_03v3 L=0.28U W=2U AS=1P AD=1P PS=5U PD=5U
M$326 \$42 MI1 \$43 VSS nfet_03v3 L=0.28U W=3U AS=1.5P AD=1.5P PS=7U PD=7U
M$327 \$43 P1 \$44 VSS nfet_03v3 L=0.28U W=3U AS=1.5P AD=1.5P PS=7U PD=7U
M$328 \$47 \$45 \$46 VSS nfet_03v3 L=0.28U W=2U AS=1P AD=1P PS=5U PD=5U
M$329 \$57 MI1 \$58 VSS nfet_03v3 L=0.28U W=2U AS=1P AD=1P PS=5U PD=5U
M$330 T1 CK2 XM1_NMID VSS nfet_03v3 L=0.28U W=2U AS=1P AD=1P PS=5U PD=5U
M$331 \$72 P2 \$73 VSS nfet_03v3 L=0.28U W=3U AS=1.5P AD=1.5P PS=7U PD=7U
M$332 \$74 MI2 \$72 VSS nfet_03v3 L=0.28U W=3U AS=1.5P AD=1.5P PS=7U PD=7U
M$333 \$77 \$75 \$76 VSS nfet_03v3 L=0.28U W=2U AS=1P AD=1P PS=5U PD=5U
M$334 \$87 MI2 \$88 VSS nfet_03v3 L=0.28U W=2U AS=1P AD=1P PS=5U PD=5U
M$335 T2 CK3 XM2_NMID VSS nfet_03v3 L=0.28U W=2U AS=1P AD=1P PS=5U PD=5U
M$336 MA T0 XMA_NM1 VSS nfet_03v3 L=0.28U W=3U AS=1.5P AD=1.5P PS=7U PD=7U
M$337 XMA_NM1 T1 XMA_NM2 VSS nfet_03v3 L=0.28U W=3U AS=1.5P AD=1.5P PS=7U PD=7U
M$338 XFRT_CKB VCO VSS VSS nfet_03v3 L=0.28U W=1U AS=0.5P AD=0.5P PS=3U PD=3U
M$339 XFRT_CKBB XFRT_CKB VSS VSS nfet_03v3 L=0.28U W=1U AS=0.5P AD=0.5P PS=3U
+ PD=3U
M$340 XFRT_NM XFRT_CKB DIVOUT VSS nfet_03v3 L=0.28U W=1U AS=0.5P AD=0.5P PS=3U
+ PD=3U
M$341 XFRT_NMA XFRT_NM VSS VSS nfet_03v3 L=0.28U W=1U AS=0.5P AD=0.5P PS=3U
+ PD=3U
M$342 XFRT_NMB XFRT_NMA VSS VSS nfet_03v3 L=0.28U W=1U AS=0.5P AD=0.5P PS=3U
+ PD=3U
M$343 XFRT_NM XFRT_CKBB XFRT_NMB VSS nfet_03v3 L=0.28U W=1U AS=0.5P AD=0.5P
+ PS=3U PD=3U
M$344 XFRT_NS XFRT_CKBB XFRT_NMA VSS nfet_03v3 L=0.28U W=1U AS=0.5P AD=0.5P
+ PS=3U PD=3U
M$345 FB XFRT_NS VSS VSS nfet_03v3 L=0.28U W=1U AS=0.5P AD=0.5P PS=3U PD=3U
M$346 FBB FB VSS VSS nfet_03v3 L=0.28U W=1U AS=0.5P AD=0.5P PS=3U PD=3U
M$347 XFRT_NS XFRT_CKB FBB VSS nfet_03v3 L=0.28U W=1U AS=0.5P AD=0.5P PS=3U
+ PD=3U
M$348 \$572 MO3 VSS VSS nfet_03v3 L=0.28U W=3U AS=1.5P AD=1.5P PS=7U PD=7U
M$349 \$573 \$853 VSS VSS nfet_03v3 L=0.28U W=2U AS=1P AD=1P PS=5U PD=5U
M$350 \$574 \$856 VSS VSS nfet_03v3 L=0.28U W=1U AS=0.5P AD=0.5P PS=3U PD=3U
M$351 \$575 CK3 VSS VSS nfet_03v3 L=0.28U W=1U AS=0.5P AD=0.5P PS=3U PD=3U
M$352 \$576 \$575 VSS VSS nfet_03v3 L=0.28U W=1U AS=0.5P AD=0.5P PS=3U PD=3U
M$353 \$577 \$575 \$574 VSS nfet_03v3 L=0.28U W=1U AS=0.5P AD=0.5P PS=3U PD=3U
M$354 \$578 \$577 VSS VSS nfet_03v3 L=0.28U W=1U AS=0.5P AD=0.5P PS=3U PD=3U
M$355 \$579 \$578 VSS VSS nfet_03v3 L=0.28U W=1U AS=0.5P AD=0.5P PS=3U PD=3U
M$356 \$577 \$576 \$579 VSS nfet_03v3 L=0.28U W=1U AS=0.5P AD=0.5P PS=3U PD=3U
M$357 \$580 \$576 \$578 VSS nfet_03v3 L=0.28U W=1U AS=0.5P AD=0.5P PS=3U PD=3U
M$358 \$581 \$580 VSS VSS nfet_03v3 L=0.28U W=1U AS=0.5P AD=0.5P PS=3U PD=3U
M$359 \$855 \$581 VSS VSS nfet_03v3 L=0.28U W=1U AS=0.5P AD=0.5P PS=3U PD=3U
M$360 \$580 \$575 \$855 VSS nfet_03v3 L=0.28U W=1U AS=0.5P AD=0.5P PS=3U PD=3U
M$361 CK4 \$855 VSS VSS nfet_03v3 L=0.28U W=2U AS=1P AD=1P PS=5U PD=5U
M$362 \$583 \$581 VSS VSS nfet_03v3 L=0.28U W=2U AS=1P AD=1P PS=5U PD=5U
M$363 \$584 \$857 VSS VSS nfet_03v3 L=0.28U W=1U AS=0.5P AD=0.5P PS=3U PD=3U
M$364 \$585 CK3 VSS VSS nfet_03v3 L=0.28U W=1U AS=0.5P AD=0.5P PS=3U PD=3U
M$365 \$586 \$585 VSS VSS nfet_03v3 L=0.28U W=1U AS=0.5P AD=0.5P PS=3U PD=3U
M$366 \$587 \$585 \$584 VSS nfet_03v3 L=0.28U W=1U AS=0.5P AD=0.5P PS=3U PD=3U
M$367 \$588 \$587 VSS VSS nfet_03v3 L=0.28U W=1U AS=0.5P AD=0.5P PS=3U PD=3U
M$368 \$589 \$588 VSS VSS nfet_03v3 L=0.28U W=1U AS=0.5P AD=0.5P PS=3U PD=3U
M$369 \$587 \$586 \$589 VSS nfet_03v3 L=0.28U W=1U AS=0.5P AD=0.5P PS=3U PD=3U
M$370 \$590 \$586 \$588 VSS nfet_03v3 L=0.28U W=1U AS=0.5P AD=0.5P PS=3U PD=3U
M$371 MO3 \$590 VSS VSS nfet_03v3 L=0.28U W=1U AS=0.5P AD=0.5P PS=3U PD=3U
M$372 \$591 MO3 VSS VSS nfet_03v3 L=0.28U W=1U AS=0.5P AD=0.5P PS=3U PD=3U
M$373 \$590 \$585 \$591 VSS nfet_03v3 L=0.28U W=1U AS=0.5P AD=0.5P PS=3U PD=3U
M$374 NMI3 MO4 VSS VSS nfet_03v3 L=0.28U W=1U AS=0.5P AD=0.5P PS=3U PD=3U
M$375 NMI3 SEL3 VSS VSS nfet_03v3 L=0.28U W=1U AS=0.5P AD=0.5P PS=3U PD=3U
M$376 MI3 NMI3 VSS VSS nfet_03v3 L=0.28U W=1U AS=0.5P AD=0.5P PS=3U PD=3U
M$377 XM3_NMID SEL3 VSS VSS nfet_03v3 L=0.28U W=2U AS=1P AD=1P PS=5U PD=5U
M$378 \$594 MO4 VSS VSS nfet_03v3 L=0.28U W=3U AS=1.5P AD=1.5P PS=7U PD=7U
M$379 \$595 \$862 VSS VSS nfet_03v3 L=0.28U W=2U AS=1P AD=1P PS=5U PD=5U
M$380 \$596 \$864 VSS VSS nfet_03v3 L=0.28U W=1U AS=0.5P AD=0.5P PS=3U PD=3U
M$381 \$597 CK4 VSS VSS nfet_03v3 L=0.28U W=1U AS=0.5P AD=0.5P PS=3U PD=3U
M$382 \$598 \$597 VSS VSS nfet_03v3 L=0.28U W=1U AS=0.5P AD=0.5P PS=3U PD=3U
M$383 \$599 \$597 \$596 VSS nfet_03v3 L=0.28U W=1U AS=0.5P AD=0.5P PS=3U PD=3U
M$384 \$600 \$599 VSS VSS nfet_03v3 L=0.28U W=1U AS=0.5P AD=0.5P PS=3U PD=3U
M$385 \$601 \$600 VSS VSS nfet_03v3 L=0.28U W=1U AS=0.5P AD=0.5P PS=3U PD=3U
M$386 \$599 \$598 \$601 VSS nfet_03v3 L=0.28U W=1U AS=0.5P AD=0.5P PS=3U PD=3U
M$387 \$602 \$598 \$600 VSS nfet_03v3 L=0.28U W=1U AS=0.5P AD=0.5P PS=3U PD=3U
M$388 \$603 \$602 VSS VSS nfet_03v3 L=0.28U W=1U AS=0.5P AD=0.5P PS=3U PD=3U
M$389 \$863 \$603 VSS VSS nfet_03v3 L=0.28U W=1U AS=0.5P AD=0.5P PS=3U PD=3U
M$390 \$602 \$597 \$863 VSS nfet_03v3 L=0.28U W=1U AS=0.5P AD=0.5P PS=3U PD=3U
M$391 CK5 \$863 VSS VSS nfet_03v3 L=0.28U W=2U AS=1P AD=1P PS=5U PD=5U
M$392 \$605 \$603 VSS VSS nfet_03v3 L=0.28U W=2U AS=1P AD=1P PS=5U PD=5U
M$393 \$606 \$865 VSS VSS nfet_03v3 L=0.28U W=1U AS=0.5P AD=0.5P PS=3U PD=3U
M$394 \$607 CK4 VSS VSS nfet_03v3 L=0.28U W=1U AS=0.5P AD=0.5P PS=3U PD=3U
M$395 \$608 \$607 VSS VSS nfet_03v3 L=0.28U W=1U AS=0.5P AD=0.5P PS=3U PD=3U
M$396 \$609 \$607 \$606 VSS nfet_03v3 L=0.28U W=1U AS=0.5P AD=0.5P PS=3U PD=3U
M$397 \$610 \$609 VSS VSS nfet_03v3 L=0.28U W=1U AS=0.5P AD=0.5P PS=3U PD=3U
M$398 \$611 \$610 VSS VSS nfet_03v3 L=0.28U W=1U AS=0.5P AD=0.5P PS=3U PD=3U
M$399 \$609 \$608 \$611 VSS nfet_03v3 L=0.28U W=1U AS=0.5P AD=0.5P PS=3U PD=3U
M$400 \$612 \$608 \$610 VSS nfet_03v3 L=0.28U W=1U AS=0.5P AD=0.5P PS=3U PD=3U
M$401 MO4 \$612 VSS VSS nfet_03v3 L=0.28U W=1U AS=0.5P AD=0.5P PS=3U PD=3U
M$402 \$613 MO4 VSS VSS nfet_03v3 L=0.28U W=1U AS=0.5P AD=0.5P PS=3U PD=3U
M$403 \$612 \$607 \$613 VSS nfet_03v3 L=0.28U W=1U AS=0.5P AD=0.5P PS=3U PD=3U
M$404 NMI4 MO5 VSS VSS nfet_03v3 L=0.28U W=1U AS=0.5P AD=0.5P PS=3U PD=3U
M$405 NMI4 SEL4 VSS VSS nfet_03v3 L=0.28U W=1U AS=0.5P AD=0.5P PS=3U PD=3U
M$406 MI4 NMI4 VSS VSS nfet_03v3 L=0.28U W=1U AS=0.5P AD=0.5P PS=3U PD=3U
M$407 XM4_NMID SEL4 VSS VSS nfet_03v3 L=0.28U W=2U AS=1P AD=1P PS=5U PD=5U
M$408 \$616 MO5 VSS VSS nfet_03v3 L=0.28U W=3U AS=1.5P AD=1.5P PS=7U PD=7U
M$409 \$617 \$869 VSS VSS nfet_03v3 L=0.28U W=2U AS=1P AD=1P PS=5U PD=5U
M$410 \$618 \$872 VSS VSS nfet_03v3 L=0.28U W=1U AS=0.5P AD=0.5P PS=3U PD=3U
M$411 \$619 CK5 VSS VSS nfet_03v3 L=0.28U W=1U AS=0.5P AD=0.5P PS=3U PD=3U
M$412 \$620 \$619 VSS VSS nfet_03v3 L=0.28U W=1U AS=0.5P AD=0.5P PS=3U PD=3U
M$413 \$621 \$619 \$618 VSS nfet_03v3 L=0.28U W=1U AS=0.5P AD=0.5P PS=3U PD=3U
M$414 \$622 \$621 VSS VSS nfet_03v3 L=0.28U W=1U AS=0.5P AD=0.5P PS=3U PD=3U
M$415 \$623 \$622 VSS VSS nfet_03v3 L=0.28U W=1U AS=0.5P AD=0.5P PS=3U PD=3U
M$416 \$621 \$620 \$623 VSS nfet_03v3 L=0.28U W=1U AS=0.5P AD=0.5P PS=3U PD=3U
M$417 \$624 \$620 \$622 VSS nfet_03v3 L=0.28U W=1U AS=0.5P AD=0.5P PS=3U PD=3U
M$418 \$625 \$624 VSS VSS nfet_03v3 L=0.28U W=1U AS=0.5P AD=0.5P PS=3U PD=3U
M$419 \$871 \$625 VSS VSS nfet_03v3 L=0.28U W=1U AS=0.5P AD=0.5P PS=3U PD=3U
M$420 \$624 \$619 \$871 VSS nfet_03v3 L=0.28U W=1U AS=0.5P AD=0.5P PS=3U PD=3U
M$421 CK6 \$871 VSS VSS nfet_03v3 L=0.28U W=2U AS=1P AD=1P PS=5U PD=5U
M$422 \$627 \$625 VSS VSS nfet_03v3 L=0.28U W=2U AS=1P AD=1P PS=5U PD=5U
M$423 \$628 \$873 VSS VSS nfet_03v3 L=0.28U W=1U AS=0.5P AD=0.5P PS=3U PD=3U
M$424 \$629 CK5 VSS VSS nfet_03v3 L=0.28U W=1U AS=0.5P AD=0.5P PS=3U PD=3U
M$425 \$630 \$629 VSS VSS nfet_03v3 L=0.28U W=1U AS=0.5P AD=0.5P PS=3U PD=3U
M$426 \$631 \$629 \$628 VSS nfet_03v3 L=0.28U W=1U AS=0.5P AD=0.5P PS=3U PD=3U
M$427 \$632 \$631 VSS VSS nfet_03v3 L=0.28U W=1U AS=0.5P AD=0.5P PS=3U PD=3U
M$428 \$633 \$632 VSS VSS nfet_03v3 L=0.28U W=1U AS=0.5P AD=0.5P PS=3U PD=3U
M$429 \$631 \$630 \$633 VSS nfet_03v3 L=0.28U W=1U AS=0.5P AD=0.5P PS=3U PD=3U
M$430 \$634 \$630 \$632 VSS nfet_03v3 L=0.28U W=1U AS=0.5P AD=0.5P PS=3U PD=3U
M$431 MO5 \$634 VSS VSS nfet_03v3 L=0.28U W=1U AS=0.5P AD=0.5P PS=3U PD=3U
M$432 \$635 MO5 VSS VSS nfet_03v3 L=0.28U W=1U AS=0.5P AD=0.5P PS=3U PD=3U
M$433 \$634 \$629 \$635 VSS nfet_03v3 L=0.28U W=1U AS=0.5P AD=0.5P PS=3U PD=3U
M$434 XM5_NMID SEL5 VSS VSS nfet_03v3 L=0.28U W=2U AS=1P AD=1P PS=5U PD=5U
M$435 XMB_NM2 T5 VSS VSS nfet_03v3 L=0.28U W=3U AS=1.5P AD=1.5P PS=7U PD=7U
M$436 \$854 P3 \$572 VSS nfet_03v3 L=0.28U W=3U AS=1.5P AD=1.5P PS=7U PD=7U
M$437 \$853 MI3 \$854 VSS nfet_03v3 L=0.28U W=3U AS=1.5P AD=1.5P PS=7U PD=7U
M$438 \$856 \$855 \$573 VSS nfet_03v3 L=0.28U W=2U AS=1P AD=1P PS=5U PD=5U
M$439 \$857 MI3 \$583 VSS nfet_03v3 L=0.28U W=2U AS=1P AD=1P PS=5U PD=5U
M$440 T3 CK4 XM3_NMID VSS nfet_03v3 L=0.28U W=2U AS=1P AD=1P PS=5U PD=5U
M$441 \$861 P4 \$594 VSS nfet_03v3 L=0.28U W=3U AS=1.5P AD=1.5P PS=7U PD=7U
M$442 \$862 MI4 \$861 VSS nfet_03v3 L=0.28U W=3U AS=1.5P AD=1.5P PS=7U PD=7U
M$443 \$864 \$863 \$595 VSS nfet_03v3 L=0.28U W=2U AS=1P AD=1P PS=5U PD=5U
M$444 \$865 MI4 \$605 VSS nfet_03v3 L=0.28U W=2U AS=1P AD=1P PS=5U PD=5U
M$445 T4 CK5 XM4_NMID VSS nfet_03v3 L=0.28U W=2U AS=1P AD=1P PS=5U PD=5U
M$446 \$869 SEL5 \$870 VSS nfet_03v3 L=0.28U W=3U AS=1.5P AD=1.5P PS=7U PD=7U
M$447 \$870 P5 \$616 VSS nfet_03v3 L=0.28U W=3U AS=1.5P AD=1.5P PS=7U PD=7U
M$448 \$872 \$871 \$617 VSS nfet_03v3 L=0.28U W=2U AS=1P AD=1P PS=5U PD=5U
M$449 \$873 SEL5 \$627 VSS nfet_03v3 L=0.28U W=2U AS=1P AD=1P PS=5U PD=5U
M$450 T5 CK6 XM5_NMID VSS nfet_03v3 L=0.28U W=2U AS=1P AD=1P PS=5U PD=5U
M$451 MB T3 XMB_NM1 VSS nfet_03v3 L=0.28U W=3U AS=1.5P AD=1.5P PS=7U PD=7U
M$452 XMB_NM1 T4 XMB_NM2 VSS nfet_03v3 L=0.28U W=3U AS=1.5P AD=1.5P PS=7U PD=7U
.ENDS divider_chain
