* Extracted by KLayout with GF180MCU LVS runset on : 22/09/2026 22:03

.SUBCKT div23_cell CKOUT VSS MODOUT CKIN MODIN P VDD
M$1 VDD \$19 \$20 VDD pfet_03v3 L=0.28U W=2.5U AS=1.25P AD=1.25P PS=6U PD=6U
M$2 VDD \$20 \$21 VDD pfet_03v3 L=0.28U W=2.5U AS=1.25P AD=1.25P PS=6U PD=6U
M$3 VDD \$17 \$18 VDD pfet_03v3 L=0.28U W=2.5U AS=1.25P AD=1.25P PS=6U PD=6U
M$4 VDD \$11 \$12 VDD pfet_03v3 L=0.28U W=2.5U AS=1.25P AD=1.25P PS=6U PD=6U
M$5 VDD \$58 CKOUT VDD pfet_03v3 L=0.28U W=5U AS=2.5P AD=2.5P PS=11U PD=11U
M$6 \$58 \$9 \$13 VDD pfet_03v3 L=0.28U W=2.5U AS=1.25P AD=1.25P PS=6U PD=6U
M$7 VDD \$59 \$6 VDD pfet_03v3 L=0.28U W=2.5U AS=1.25P AD=1.25P PS=6U PD=6U
M$8 VDD \$14 \$58 VDD pfet_03v3 L=0.28U W=2.5U AS=1.25P AD=1.25P PS=6U PD=6U
M$9 VDD P \$57 VDD pfet_03v3 L=0.28U W=2.5U AS=1.25P AD=1.25P PS=6U PD=6U
M$10 VDD MODOUT \$57 VDD pfet_03v3 L=0.28U W=2.5U AS=1.25P AD=1.25P PS=6U PD=6U
M$11 VDD \$13 \$14 VDD pfet_03v3 L=0.28U W=2.5U AS=1.25P AD=1.25P PS=6U PD=6U
M$12 VDD \$58 \$59 VDD pfet_03v3 L=0.28U W=2.5U AS=1.25P AD=1.25P PS=6U PD=6U
M$13 VDD CKIN \$8 VDD pfet_03v3 L=0.28U W=2.5U AS=1.25P AD=1.25P PS=6U PD=6U
M$14 VDD MODIN \$57 VDD pfet_03v3 L=0.28U W=2.5U AS=1.25P AD=1.25P PS=6U PD=6U
M$15 VDD \$22 MODOUT VDD pfet_03v3 L=0.28U W=2.5U AS=1.25P AD=1.25P PS=6U PD=6U
M$16 \$23 \$18 \$22 VDD pfet_03v3 L=0.28U W=2.5U AS=1.25P AD=1.25P PS=6U PD=6U
M$17 \$20 \$17 \$22 VDD pfet_03v3 L=0.28U W=2.5U AS=1.25P AD=1.25P PS=6U PD=6U
M$18 VDD \$8 \$9 VDD pfet_03v3 L=0.28U W=2.5U AS=1.25P AD=1.25P PS=6U PD=6U
M$19 VDD \$10 \$11 VDD pfet_03v3 L=0.28U W=2.5U AS=1.25P AD=1.25P PS=6U PD=6U
M$20 VDD CKIN \$17 VDD pfet_03v3 L=0.28U W=2.5U AS=1.25P AD=1.25P PS=6U PD=6U
M$21 \$11 \$8 \$13 VDD pfet_03v3 L=0.28U W=2.5U AS=1.25P AD=1.25P PS=6U PD=6U
M$22 VDD \$57 \$59 VDD pfet_03v3 L=0.28U W=2.5U AS=1.25P AD=1.25P PS=6U PD=6U
M$23 VDD \$60 \$16 VDD pfet_03v3 L=0.28U W=2.5U AS=1.25P AD=1.25P PS=6U PD=6U
M$24 \$6 \$9 \$10 VDD pfet_03v3 L=0.28U W=2.5U AS=1.25P AD=1.25P PS=6U PD=6U
M$25 \$16 \$18 \$19 VDD pfet_03v3 L=0.28U W=2.5U AS=1.25P AD=1.25P PS=6U PD=6U
M$26 \$21 \$17 \$19 VDD pfet_03v3 L=0.28U W=2.5U AS=1.25P AD=1.25P PS=6U PD=6U
M$27 \$12 \$8 \$10 VDD pfet_03v3 L=0.28U W=2.5U AS=1.25P AD=1.25P PS=6U PD=6U
M$28 VDD MODOUT \$23 VDD pfet_03v3 L=0.28U W=2.5U AS=1.25P AD=1.25P PS=6U PD=6U
M$29 VDD \$14 \$60 VDD pfet_03v3 L=0.28U W=2.5U AS=1.25P AD=1.25P PS=6U PD=6U
M$30 VDD MODIN \$60 VDD pfet_03v3 L=0.28U W=2.5U AS=1.25P AD=1.25P PS=6U PD=6U
M$31 \$19 \$17 \$16 VSS nfet_03v3 L=0.28U W=1U AS=0.5P AD=0.5P PS=3U PD=3U
M$32 \$8 CKIN VSS VSS nfet_03v3 L=0.28U W=1U AS=0.5P AD=0.5P PS=3U PD=3U
M$33 \$5 \$57 VSS VSS nfet_03v3 L=0.28U W=2U AS=1P AD=1P PS=5U PD=5U
M$34 \$21 \$20 VSS VSS nfet_03v3 L=0.28U W=1U AS=0.5P AD=0.5P PS=3U PD=3U
M$35 \$10 \$9 \$12 VSS nfet_03v3 L=0.28U W=1U AS=0.5P AD=0.5P PS=3U PD=3U
M$36 \$20 \$19 VSS VSS nfet_03v3 L=0.28U W=1U AS=0.5P AD=0.5P PS=3U PD=3U
M$37 \$15 \$14 VSS VSS nfet_03v3 L=0.28U W=2U AS=1P AD=1P PS=5U PD=5U
M$38 \$19 \$18 \$21 VSS nfet_03v3 L=0.28U W=1U AS=0.5P AD=0.5P PS=3U PD=3U
M$39 \$17 CKIN VSS VSS nfet_03v3 L=0.28U W=1U AS=0.5P AD=0.5P PS=3U PD=3U
M$40 \$16 \$60 VSS VSS nfet_03v3 L=0.28U W=1U AS=0.5P AD=0.5P PS=3U PD=3U
M$41 \$10 \$8 \$6 VSS nfet_03v3 L=0.28U W=1U AS=0.5P AD=0.5P PS=3U PD=3U
M$42 \$22 \$17 \$23 VSS nfet_03v3 L=0.28U W=1U AS=0.5P AD=0.5P PS=3U PD=3U
M$43 \$60 MODIN \$15 VSS nfet_03v3 L=0.28U W=2U AS=1P AD=1P PS=5U PD=5U
M$44 \$6 \$59 VSS VSS nfet_03v3 L=0.28U W=1U AS=0.5P AD=0.5P PS=3U PD=3U
M$45 CKOUT \$58 VSS VSS nfet_03v3 L=0.28U W=2U AS=1P AD=1P PS=5U PD=5U
M$46 \$4 MODOUT VSS VSS nfet_03v3 L=0.28U W=3U AS=1.5P AD=1.5P PS=7U PD=7U
M$47 \$22 \$18 \$20 VSS nfet_03v3 L=0.28U W=1U AS=0.5P AD=0.5P PS=3U PD=3U
M$48 \$13 \$9 \$11 VSS nfet_03v3 L=0.28U W=1U AS=0.5P AD=0.5P PS=3U PD=3U
M$49 \$14 \$13 VSS VSS nfet_03v3 L=0.28U W=1U AS=0.5P AD=0.5P PS=3U PD=3U
M$50 \$18 \$17 VSS VSS nfet_03v3 L=0.28U W=1U AS=0.5P AD=0.5P PS=3U PD=3U
M$51 \$9 \$8 VSS VSS nfet_03v3 L=0.28U W=1U AS=0.5P AD=0.5P PS=3U PD=3U
M$52 \$12 \$11 VSS VSS nfet_03v3 L=0.28U W=1U AS=0.5P AD=0.5P PS=3U PD=3U
M$53 \$11 \$10 VSS VSS nfet_03v3 L=0.28U W=1U AS=0.5P AD=0.5P PS=3U PD=3U
M$54 \$13 \$8 \$58 VSS nfet_03v3 L=0.28U W=1U AS=0.5P AD=0.5P PS=3U PD=3U
M$55 \$58 \$14 VSS VSS nfet_03v3 L=0.28U W=1U AS=0.5P AD=0.5P PS=3U PD=3U
M$56 \$59 \$58 \$5 VSS nfet_03v3 L=0.28U W=2U AS=1P AD=1P PS=5U PD=5U
M$57 \$57 MODIN \$56 VSS nfet_03v3 L=0.28U W=3U AS=1.5P AD=1.5P PS=7U PD=7U
M$58 \$23 MODOUT VSS VSS nfet_03v3 L=0.28U W=1U AS=0.5P AD=0.5P PS=3U PD=3U
M$59 MODOUT \$22 VSS VSS nfet_03v3 L=0.28U W=1U AS=0.5P AD=0.5P PS=3U PD=3U
M$60 \$56 P \$4 VSS nfet_03v3 L=0.28U W=3U AS=1.5P AD=1.5P PS=7U PD=7U
.ENDS div23_cell
