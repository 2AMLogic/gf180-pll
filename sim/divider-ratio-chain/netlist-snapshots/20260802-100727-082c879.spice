* Frozen netlist snapshot for record 20260802-100727-082c879
* sources    : divider_chain.spice + tb_divider_chain.sp (composed at record time, in this order)
* sha256     : 001c3fb70687a5a5a3cc0e58e435727c149cc7f6944c3d18a623e7024b653adc (of this composed text)
* This is a verbatim composition taken at record time. Do not edit.

* ---- design/netlist/divider_chain.spice (sha256 bcdaece6dab79a3bfe6bb50419152bd278cb0cfb28c3020878303a2d2837c80f)
* gf180-pll :: divider_chain -- generated by design/netlist.sh from divider_chain.sch
* xschem XSCHEM V3.4.7; do not edit by hand.
** sch_path: design/divider_chain.sch
.subckt divider_chain VCO P0 P1 P2 P3 P4 P5 SEL0 SEL1 SEL2 SEL3 SEL4 SEL5 DIVOUT FB VDD_DIV VSS
*.ipin VCO
*.ipin P0
*.ipin P1
*.ipin P2
*.ipin P3
*.ipin P4
*.ipin P5
*.ipin SEL0
*.ipin SEL1
*.ipin SEL2
*.ipin SEL3
*.ipin SEL4
*.ipin SEL5
*.opin DIVOUT
*.opin FB
*.iopin VDD_DIV
*.iopin VSS
XD0 VCO MI0 P0 CK1 MO0 VDD_DIV VSS div23_cell
XD1 CK1 MI1 P1 CK2 MO1 VDD_DIV VSS div23_cell
XD2 CK2 MI2 P2 CK3 MO2 VDD_DIV VSS div23_cell
XD3 CK3 MI3 P3 CK4 MO3 VDD_DIV VSS div23_cell
XD4 CK4 MI4 P4 CK5 MO4 VDD_DIV VSS div23_cell
XD5 CK5 SEL5 P5 CK6 MO5 VDD_DIV VSS div23_cell
XNR0 MO1 SEL0 NMI0 VDD_DIV VSS nor2_3v3
XIV0 NMI0 MI0 VDD_DIV VSS inv_3v3
XNR1 MO2 SEL1 NMI1 VDD_DIV VSS nor2_3v3
XIV1 NMI1 MI1 VDD_DIV VSS inv_3v3
XNR2 MO3 SEL2 NMI2 VDD_DIV VSS nor2_3v3
XIV2 NMI2 MI2 VDD_DIV VSS inv_3v3
XNR3 MO4 SEL3 NMI3 VDD_DIV VSS nor2_3v3
XIV3 NMI3 MI3 VDD_DIV VSS inv_3v3
XNR4 MO5 SEL4 NMI4 VDD_DIV VSS nor2_3v3
XIV4 NMI4 MI4 VDD_DIV VSS inv_3v3
XM0 CK1 SEL0 T0 VDD_DIV VSS nand2_3v3
XM1 CK2 SEL1 T1 VDD_DIV VSS nand2_3v3
XM2 CK3 SEL2 T2 VDD_DIV VSS nand2_3v3
XM3 CK4 SEL3 T3 VDD_DIV VSS nand2_3v3
XM4 CK5 SEL4 T4 VDD_DIV VSS nand2_3v3
XM5 CK6 SEL5 T5 VDD_DIV VSS nand2_3v3
XMA T0 T1 T2 MA VDD_DIV VSS nand3_3v3
XMB T3 T4 T5 MB VDD_DIV VSS nand3_3v3
XMNO MA MB DIVOUTB VDD_DIV VSS nor2_3v3
XIDO DIVOUTB DIVOUT VDD_DIV VSS inv2x_3v3
XFRT DIVOUT VCO FB FBB VDD_DIV VSS dff_tg_3v3
.ends

* expanding   symbol:  div23_cell.sym # of pins=7
** sym_path: design/div23_cell.sym
** sch_path: design/div23_cell.sch
.subckt div23_cell CKIN MODIN P CKOUT MODOUT VDD VSS
*.ipin CKIN
*.ipin MODIN
*.ipin P
*.opin CKOUT
*.opin MODOUT
*.iopin VDD
*.iopin VSS
XN3 MODIN P MODOUT SB VDD VSS nand3_3v3
XN2Q QB SB DQN VDD VSS nand2_3v3
XIQ DQN DQ VDD VSS inv_3v3
XFQ DQ CKIN Q QB VDD VSS dff_tg_3v3
XICKO QB CKOUT VDD VSS inv2x_3v3
XN2M MODIN Q NMO VDD VSS nand2_3v3
XIM NMO DMO VDD VSS inv_3v3
XFMO DMO CKIN MODOUT MOB VDD VSS dff_tg_3v3
.ends

* expanding   symbol:  nor2_3v3.sym # of pins=5
** sym_path: design/nor2_3v3.sym
** sch_path: design/nor2_3v3.sch
.subckt nor2_3v3 A B Y VDD VSS
*.ipin A
*.ipin B
*.opin Y
*.iopin VDD
*.iopin VSS
XMPA PMID A VDD VDD pfet_03v3 L=0.28u W=5u nf=1 ad='int((nf+1)/2) * W/nf * 0.18u' as='int((nf+2)/2) * W/nf * 0.18u' pd='2*int((nf+1)/2) * (W/nf + 0.18u)'
+ ps='2*int((nf+2)/2) * (W/nf + 0.18u)' nrd='0.18u / W' nrs='0.18u / W' sa=0 sb=0 sd=0 m=1
XMPB Y B PMID VDD pfet_03v3 L=0.28u W=5u nf=1 ad='int((nf+1)/2) * W/nf * 0.18u' as='int((nf+2)/2) * W/nf * 0.18u' pd='2*int((nf+1)/2) * (W/nf + 0.18u)'
+ ps='2*int((nf+2)/2) * (W/nf + 0.18u)' nrd='0.18u / W' nrs='0.18u / W' sa=0 sb=0 sd=0 m=1
XMNA Y A VSS VSS nfet_03v3 L=0.28u W=1u nf=1 ad='int((nf+1)/2) * W/nf * 0.18u' as='int((nf+2)/2) * W/nf * 0.18u' pd='2*int((nf+1)/2) * (W/nf + 0.18u)'
+ ps='2*int((nf+2)/2) * (W/nf + 0.18u)' nrd='0.18u / W' nrs='0.18u / W' sa=0 sb=0 sd=0 m=1
XMNB Y B VSS VSS nfet_03v3 L=0.28u W=1u nf=1 ad='int((nf+1)/2) * W/nf * 0.18u' as='int((nf+2)/2) * W/nf * 0.18u' pd='2*int((nf+1)/2) * (W/nf + 0.18u)'
+ ps='2*int((nf+2)/2) * (W/nf + 0.18u)' nrd='0.18u / W' nrs='0.18u / W' sa=0 sb=0 sd=0 m=1
.ends

* expanding   symbol:  inv_3v3.sym # of pins=4
** sym_path: design/inv_3v3.sym
** sch_path: design/inv_3v3.sch
.subckt inv_3v3 A Y VDD VSS
*.ipin A
*.opin Y
*.iopin VDD
*.iopin VSS
XMP Y A VDD VDD pfet_03v3 L=0.28u W=2.5u nf=1 ad='int((nf+1)/2) * W/nf * 0.18u' as='int((nf+2)/2) * W/nf * 0.18u' pd='2*int((nf+1)/2) * (W/nf + 0.18u)'
+ ps='2*int((nf+2)/2) * (W/nf + 0.18u)' nrd='0.18u / W' nrs='0.18u / W' sa=0 sb=0 sd=0 m=1
XMN Y A VSS VSS nfet_03v3 L=0.28u W=1u nf=1 ad='int((nf+1)/2) * W/nf * 0.18u' as='int((nf+2)/2) * W/nf * 0.18u' pd='2*int((nf+1)/2) * (W/nf + 0.18u)'
+ ps='2*int((nf+2)/2) * (W/nf + 0.18u)' nrd='0.18u / W' nrs='0.18u / W' sa=0 sb=0 sd=0 m=1
.ends

* expanding   symbol:  nand2_3v3.sym # of pins=5
** sym_path: design/nand2_3v3.sym
** sch_path: design/nand2_3v3.sch
.subckt nand2_3v3 A B Y VDD VSS
*.ipin A
*.ipin B
*.opin Y
*.iopin VDD
*.iopin VSS
XMPA Y A VDD VDD pfet_03v3 L=0.28u W=2.5u nf=1 ad='int((nf+1)/2) * W/nf * 0.18u' as='int((nf+2)/2) * W/nf * 0.18u' pd='2*int((nf+1)/2) * (W/nf + 0.18u)'
+ ps='2*int((nf+2)/2) * (W/nf + 0.18u)' nrd='0.18u / W' nrs='0.18u / W' sa=0 sb=0 sd=0 m=1
XMPB Y B VDD VDD pfet_03v3 L=0.28u W=2.5u nf=1 ad='int((nf+1)/2) * W/nf * 0.18u' as='int((nf+2)/2) * W/nf * 0.18u' pd='2*int((nf+1)/2) * (W/nf + 0.18u)'
+ ps='2*int((nf+2)/2) * (W/nf + 0.18u)' nrd='0.18u / W' nrs='0.18u / W' sa=0 sb=0 sd=0 m=1
XMNA Y A NMID VSS nfet_03v3 L=0.28u W=2u nf=1 ad='int((nf+1)/2) * W/nf * 0.18u' as='int((nf+2)/2) * W/nf * 0.18u' pd='2*int((nf+1)/2) * (W/nf + 0.18u)'
+ ps='2*int((nf+2)/2) * (W/nf + 0.18u)' nrd='0.18u / W' nrs='0.18u / W' sa=0 sb=0 sd=0 m=1
XMNB NMID B VSS VSS nfet_03v3 L=0.28u W=2u nf=1 ad='int((nf+1)/2) * W/nf * 0.18u' as='int((nf+2)/2) * W/nf * 0.18u' pd='2*int((nf+1)/2) * (W/nf + 0.18u)'
+ ps='2*int((nf+2)/2) * (W/nf + 0.18u)' nrd='0.18u / W' nrs='0.18u / W' sa=0 sb=0 sd=0 m=1
.ends

* expanding   symbol:  nand3_3v3.sym # of pins=6
** sym_path: design/nand3_3v3.sym
** sch_path: design/nand3_3v3.sch
.subckt nand3_3v3 A B C Y VDD VSS
*.ipin A
*.ipin B
*.ipin C
*.opin Y
*.iopin VDD
*.iopin VSS
XMPA Y A VDD VDD pfet_03v3 L=0.28u W=2.5u nf=1 ad='int((nf+1)/2) * W/nf * 0.18u' as='int((nf+2)/2) * W/nf * 0.18u' pd='2*int((nf+1)/2) * (W/nf + 0.18u)'
+ ps='2*int((nf+2)/2) * (W/nf + 0.18u)' nrd='0.18u / W' nrs='0.18u / W' sa=0 sb=0 sd=0 m=1
XMPB Y B VDD VDD pfet_03v3 L=0.28u W=2.5u nf=1 ad='int((nf+1)/2) * W/nf * 0.18u' as='int((nf+2)/2) * W/nf * 0.18u' pd='2*int((nf+1)/2) * (W/nf + 0.18u)'
+ ps='2*int((nf+2)/2) * (W/nf + 0.18u)' nrd='0.18u / W' nrs='0.18u / W' sa=0 sb=0 sd=0 m=1
XMPC Y C VDD VDD pfet_03v3 L=0.28u W=2.5u nf=1 ad='int((nf+1)/2) * W/nf * 0.18u' as='int((nf+2)/2) * W/nf * 0.18u' pd='2*int((nf+1)/2) * (W/nf + 0.18u)'
+ ps='2*int((nf+2)/2) * (W/nf + 0.18u)' nrd='0.18u / W' nrs='0.18u / W' sa=0 sb=0 sd=0 m=1
XMNA Y A NM1 VSS nfet_03v3 L=0.28u W=3u nf=1 ad='int((nf+1)/2) * W/nf * 0.18u' as='int((nf+2)/2) * W/nf * 0.18u' pd='2*int((nf+1)/2) * (W/nf + 0.18u)'
+ ps='2*int((nf+2)/2) * (W/nf + 0.18u)' nrd='0.18u / W' nrs='0.18u / W' sa=0 sb=0 sd=0 m=1
XMNB NM1 B NM2 VSS nfet_03v3 L=0.28u W=3u nf=1 ad='int((nf+1)/2) * W/nf * 0.18u' as='int((nf+2)/2) * W/nf * 0.18u' pd='2*int((nf+1)/2) * (W/nf + 0.18u)'
+ ps='2*int((nf+2)/2) * (W/nf + 0.18u)' nrd='0.18u / W' nrs='0.18u / W' sa=0 sb=0 sd=0 m=1
XMNC NM2 C VSS VSS nfet_03v3 L=0.28u W=3u nf=1 ad='int((nf+1)/2) * W/nf * 0.18u' as='int((nf+2)/2) * W/nf * 0.18u' pd='2*int((nf+1)/2) * (W/nf + 0.18u)'
+ ps='2*int((nf+2)/2) * (W/nf + 0.18u)' nrd='0.18u / W' nrs='0.18u / W' sa=0 sb=0 sd=0 m=1
.ends

* expanding   symbol:  inv2x_3v3.sym # of pins=4
** sym_path: design/inv2x_3v3.sym
** sch_path: design/inv2x_3v3.sch
.subckt inv2x_3v3 A Y VDD VSS
*.ipin A
*.opin Y
*.iopin VDD
*.iopin VSS
XMP Y A VDD VDD pfet_03v3 L=0.28u W=5u nf=1 ad='int((nf+1)/2) * W/nf * 0.18u' as='int((nf+2)/2) * W/nf * 0.18u' pd='2*int((nf+1)/2) * (W/nf + 0.18u)'
+ ps='2*int((nf+2)/2) * (W/nf + 0.18u)' nrd='0.18u / W' nrs='0.18u / W' sa=0 sb=0 sd=0 m=1
XMN Y A VSS VSS nfet_03v3 L=0.28u W=2u nf=1 ad='int((nf+1)/2) * W/nf * 0.18u' as='int((nf+2)/2) * W/nf * 0.18u' pd='2*int((nf+1)/2) * (W/nf + 0.18u)'
+ ps='2*int((nf+2)/2) * (W/nf + 0.18u)' nrd='0.18u / W' nrs='0.18u / W' sa=0 sb=0 sd=0 m=1
.ends

* expanding   symbol:  dff_tg_3v3.sym # of pins=6
** sym_path: design/dff_tg_3v3.sym
** sch_path: design/dff_tg_3v3.sch
.subckt dff_tg_3v3 D CK Q QB VDD VSS
*.ipin D
*.ipin CK
*.opin Q
*.opin QB
*.iopin VDD
*.iopin VSS
XICKB CK CKB VDD VSS inv_3v3
XICKBB CKB CKBB VDD VSS inv_3v3
XTGMI D NM CKB CKBB VDD VSS tgate_3v3
XIA NM NMA VDD VSS inv_3v3
XIB NMA NMB VDD VSS inv_3v3
XTGMF NMB NM CKBB CKB VDD VSS tgate_3v3
XTGSI NMA NS CKBB CKB VDD VSS tgate_3v3
XIC NS Q VDD VSS inv_3v3
XID Q QB VDD VSS inv_3v3
XTGSF QB NS CKB CKBB VDD VSS tgate_3v3
.ends

* expanding   symbol:  tgate_3v3.sym # of pins=6
** sym_path: design/tgate_3v3.sym
** sch_path: design/tgate_3v3.sch
.subckt tgate_3v3 A Y GN GP VDD VSS
*.iopin A
*.iopin Y
*.ipin GN
*.ipin GP
*.iopin VDD
*.iopin VSS
XMP Y GP A VDD pfet_03v3 L=0.28u W=2.5u nf=1 ad='int((nf+1)/2) * W/nf * 0.18u' as='int((nf+2)/2) * W/nf * 0.18u' pd='2*int((nf+1)/2) * (W/nf + 0.18u)'
+ ps='2*int((nf+2)/2) * (W/nf + 0.18u)' nrd='0.18u / W' nrs='0.18u / W' sa=0 sb=0 sd=0 m=1
XMN A GN Y VSS nfet_03v3 L=0.28u W=1u nf=1 ad='int((nf+1)/2) * W/nf * 0.18u' as='int((nf+2)/2) * W/nf * 0.18u' pd='2*int((nf+1)/2) * (W/nf + 0.18u)'
+ ps='2*int((nf+2)/2) * (W/nf + 0.18u)' nrd='0.18u / W' nrs='0.18u / W' sa=0 sb=0 sd=0 m=1
.ends

* ---- sim/divider-ratio-chain/testbench/tb_divider_chain.sp (sha256 c9f11fc479c62263d4f3a50cc7954de44726c8a314462ca20d803001e19e6ef1)
* gf180-pll :: divider-ratio-chain :: full divider_chain testbench (DR-001 Decision 3)
*
* One divider_chain instance (six div23_cells + chain-length termination +
* output multiplexer + VCO-clocked retiming flop) driven at kf, programmed to
* one integer N per run through the one-hot chain-length code SEL and the
* modulus bits P:
*
*   N = 2^k + sum(P_i . 2^i)  for i < k,  SEL_(k-1) = 1
*
* Measured per run:
*   n_fb      the retimed FB period in units of the VCO period -- must equal N
*   ndo       the same for the un-retimed DIVOUT node, over the same interval
*
* Both are measured only AFTER a full output period (kn VCO periods) has been
* skipped. That skip is not padding: the thirteen flops come out of the DC
* operating point in an arbitrary state, and the modulus chain needs one full
* pass -- one output period -- before its ripple-back mod signals are correct.
* Measured without the skip, the FIRST output period reads N-1 at some N and
* corners (observed at ff/-40 C/3.63 V for N = 12, 13, 16, 17) while every
* period after it is exact. That is a start-up transient, not a division
* error, and skipping it is the honest way to exclude it -- as opposed to
* widening the tolerance until it disappears.
*   t_arr     DIVOUT arrival time referred to the VCO rising edge that caused
*             it = the chain's accumulated clk->Q plus the output-mux delay.
*             This is the quantity the retiming flop's setup budget is spent
*             on (DR-001: "one VCO period minus the chain's accumulated
*             clk->Q"), so setup margin = T_vco - t_arr - t_setup, with
*             t_setup joined from sim/divider-ratio-dff at the same PVT point
*             (this manifest's 'derived' retiming_margin.csv table).
*   t_rtcq    the retiming flop's own clk->Q, i.e. the constant, N-independent
*             feedback delay the PFD sees (DR-001's interface contract to #9).
*   fbpw      FB high time -- must be >= the PFD reset delay (#9's contract).
*
* Fed by sim/harness: process/temp/vdd_val as usual, plus this manifest's
* 'point' sweep axis params kf/ktstep/ktstop/kn/ksel0..5/kp0..5 (one point per
* (input rate, programmed N) combination actually run -- see
* sim/harness/README.md "Sweeping beyond the PVT grid").
*
* divider_chain is composed ahead of this fragment by the manifest's 'dut' key
* (design/netlist/divider_chain.spice, exported from design/divider_chain.sch,
* itself instantiating design/div23_cell.sch), so the frozen netlist snapshot
* is DUT + this file in one self-contained deck.

.param tvco='1/kf'
.param ttr='tvco/50'
.param ttd='tvco'
.param tck0='ttd+ttr/2'

vdiv vdd_div 0 dc 'vdd_val'
vvco vco 0 pulse(0 'vdd_val' 'ttd' 'ttr' 'ttr' 'tvco/2-ttr' 'tvco')

vs0 sel0 0 dc 'ksel0*vdd_val'
vs1 sel1 0 dc 'ksel1*vdd_val'
vs2 sel2 0 dc 'ksel2*vdd_val'
vs3 sel3 0 dc 'ksel3*vdd_val'
vs4 sel4 0 dc 'ksel4*vdd_val'
vs5 sel5 0 dc 'ksel5*vdd_val'
vq0 pb0 0 dc 'kp0*vdd_val'
vq1 pb1 0 dc 'kp1*vdd_val'
vq2 pb2 0 dc 'kp2*vdd_val'
vq3 pb3 0 dc 'kp3*vdd_val'
vq4 pb4 0 dc 'kp4*vdd_val'
vq5 pb5 0 dc 'kp5*vdd_val'

xchain vco pb0 pb1 pb2 pb3 pb4 pb5 sel0 sel1 sel2 sel3 sel4 sel5
+ divout fb vdd_div 0 divider_chain

* Skip one full output period of start-up before looking for any edge.
.param tskip='ttd+kn*tvco'
