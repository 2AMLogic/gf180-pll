* Extracted by KLayout with GF180MCU LVS runset on : 11/09/2026 03:16

.SUBCKT vco_ring GND_VCO S1.Y|Y1 S2.Y|Y2 S3.Y|Y3 S4.Y|Y4 S5.Y|Y5|Y5_CLK_IN VBN
+ VBP VDD_VCO
M$1 VDD_VCO VBP \$28 VDD_VCO pfet_03v3 L=0.5U W=10U AS=5P AD=5P PS=21U PD=21U
M$2 VDD_VCO VBP \$27 VDD_VCO pfet_03v3 L=0.5U W=10U AS=5P AD=5P PS=21U PD=21U
M$3 VDD_VCO VBP \$29 VDD_VCO pfet_03v3 L=0.5U W=10U AS=5P AD=5P PS=21U PD=21U
M$4 VDD_VCO VBP \$25 VDD_VCO pfet_03v3 L=0.5U W=10U AS=5P AD=5P PS=21U PD=21U
M$5 VDD_VCO VBP \$26 VDD_VCO pfet_03v3 L=0.5U W=10U AS=5P AD=5P PS=21U PD=21U
M$6 \$28 S3.Y|Y3 S4.Y|Y4 VDD_VCO pfet_03v3 L=0.28U W=5U AS=2.5P AD=2.5P PS=11U
+ PD=11U
M$7 \$29 S4.Y|Y4 S5.Y|Y5|Y5_CLK_IN VDD_VCO pfet_03v3 L=0.28U W=5U AS=2.5P
+ AD=2.5P PS=11U PD=11U
M$8 \$27 S2.Y|Y2 S3.Y|Y3 VDD_VCO pfet_03v3 L=0.28U W=5U AS=2.5P AD=2.5P PS=11U
+ PD=11U
M$9 \$26 S1.Y|Y1 S2.Y|Y2 VDD_VCO pfet_03v3 L=0.28U W=5U AS=2.5P AD=2.5P PS=11U
+ PD=11U
M$10 \$25 S5.Y|Y5|Y5_CLK_IN S1.Y|Y1 VDD_VCO pfet_03v3 L=0.28U W=5U AS=2.5P
+ AD=2.5P PS=11U PD=11U
M$11 S5.Y|Y5|Y5_CLK_IN S4.Y|Y4 \$9 GND_VCO nfet_03v3 L=0.28U W=2U AS=1P AD=1P
+ PS=5U PD=5U
M$12 S4.Y|Y4 S3.Y|Y3 \$8 GND_VCO nfet_03v3 L=0.28U W=2U AS=1P AD=1P PS=5U PD=5U
M$13 S3.Y|Y3 S2.Y|Y2 \$7 GND_VCO nfet_03v3 L=0.28U W=2U AS=1P AD=1P PS=5U PD=5U
M$14 S1.Y|Y1 S5.Y|Y5|Y5_CLK_IN \$5 GND_VCO nfet_03v3 L=0.28U W=2U AS=1P AD=1P
+ PS=5U PD=5U
M$15 \$6 VBN GND_VCO GND_VCO nfet_03v3 L=0.5U W=4U AS=2P AD=2P PS=9U PD=9U
M$16 \$9 VBN GND_VCO GND_VCO nfet_03v3 L=0.5U W=4U AS=2P AD=2P PS=9U PD=9U
M$17 S2.Y|Y2 S1.Y|Y1 \$6 GND_VCO nfet_03v3 L=0.28U W=2U AS=1P AD=1P PS=5U PD=5U
M$18 \$7 VBN GND_VCO GND_VCO nfet_03v3 L=0.5U W=4U AS=2P AD=2P PS=9U PD=9U
M$19 \$8 VBN GND_VCO GND_VCO nfet_03v3 L=0.5U W=4U AS=2P AD=2P PS=9U PD=9U
M$20 \$5 VBN GND_VCO GND_VCO nfet_03v3 L=0.5U W=4U AS=2P AD=2P PS=9U PD=9U
.ENDS vco_ring
