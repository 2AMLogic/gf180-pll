* gf180-pll :: vco-tuning-range :: supply-step and supply-ripple jitter
*
* sim/harness netlist FRAGMENT (see sim/harness/README.md), and the `jit` phase
* of the two-deck supply manifest next to this file. The DUT is the committed
* export design/netlist/vco.spice, composed ahead of this fragment by the
* manifest's `dut` key.
*
* Migrated from the sim/lib/simenv.sh-based tb_vco_supply_jitter.sp +
* run_supply.sh pair (issue #43). The measured circuit, the stimulus and the
* extraction criterion are unchanged: same three-copy topology, same
* rail-tracking band code, same .ic start-up, same 0.1 V step / 0.05 V ripple,
* the same window (6 settle periods + 4 whole ripple periods, >= 64 cycles,
* step at the window midpoint), and the same interpolated half-supply-crossing
* extraction -- now in derive_supply.py instead of jitter_extract.py.
*
* DR-001's Consequences section names supply noise the accepted risk of the
* current-starved single-ended ring, and names this testbench as the evidence
* #8 owes: "a supply-step/supply-noise jitter testbench, not just a
* clean-supply Kvco sweep. This is the number most likely to force a
* supersede."
*
* Measurement topology -- three independent copies of the whole VCO at one PVT
* point, one band code and one control voltage, differing ONLY in what drives
* their supply rail:
*
*   XQ  quiet rail, dc vdd_val. This copy is the **numerical noise floor**: any
*       cycle-to-cycle variation it shows is the transient solver's own local
*       truncation error, not circuit behaviour. Every jitter number from the
*       other two copies is reported against this floor, so the record can say
*       whether the supply-induced jitter is resolvable at all.
*   XS  rail with a single fast STEP of `astep` volts at t = `w_stepon`,
*       `tedge` edge. Gives the transient supply-pushing coefficient (which is
*       not assumed equal to the dc one) and the timing error a supply droop
*       accumulates while the loop has not yet corrected it.
*   XR  rail with a sinusoidal RIPPLE of amplitude `arip` at `w_frip`. Gives
*       peak-to-peak / RMS period jitter and the peak-to-peak time interval
*       error (TIE), which is the quantity a jitter budget actually consumes.
*
* Each copy's 3-bit band code is generated by a VCVS from that copy's own rail,
* so the static band-select code tracks the perturbed supply exactly rather
* than presenting a stale logic level to the band-select pass gates.
*
* No `.measure` reports a jitter number here. The three buffered outputs are
* written to `jit.dat` (the manifest's `raw_files`) and every reported number
* is extracted from interpolated half-supply crossings by derive_supply.py --
* `.measure` cannot report a per-cycle period sequence, and the period
* *sequence* is what jitter is. The three `.measure`d quantities the manifest
* does declare for this deck (`jsettle`, `jstepon`, `jfrip`) are the deck's own
* window parameters, reported so the reduction uses the values the simulation
* actually ran with rather than recomputing them.
*
* Devices are PDK 3.3 V thick-oxide wrappers only (DR-002 Decision 3).
*
* From the harness: vdd_val, vdd_nom, temp_c.
* From the manifest's shared params: vctrl, astep, arip, tedge.
* From the manifest's `band` sweep axis: band, b0, b1, b2.
* From the manifest's `rdiv` sweep axis: w_rdiv, w_ncyc.
* From the manifest's `fcal` sweep axis: w_fres.

* Tighter than the ngspice default (1e-3) so the quiet copy's numerical jitter
* floor sits well below the supply-induced jitter being measured. Declared as
* the phase's `options` in the manifest, not here -- a fragment does not own
* simulator settings. (Kept in this comment because the floor claim in the
* record depends on it.)

* ---------------------------------------------------------------------------
* Transient window and ripple frequency, sized in-deck.
*
* Identical estimator to the `push` phase's -- see tb_vco_pushing.spice for the
* full derivation and for why it is preserved verbatim from the pre-migration
* bash runner rather than improved. Here it is not only a window: `w_frip` IS
* the stimulus, because the campaign's ripple frequency is specified as
* f_osc/N. That is why the process-dependent term `w_fres` has to reach the
* deck at all (via the manifest's `fcal` axis) -- a ripple defined relative to
* f_osc cannot be corner-blind.
.param w_fband='exp(band*0.50077528791248915)'
.param w_ft='0.90030044582283386 + 0.0037187439426245397*temp_c - 9.6918007365767916e-07*temp_c*temp_c'
.param w_f='4.5e6 * w_fband * 1.6766917293233083 * w_ft * w_fres * (1 + (3.30 - vdd_val) * 0.36)'
* 6 estimated periods of settling, then a window holding w_ncyc whole cycles.
* w_ncyc is always >= 64 cycles AND >= 4 whole ripple periods, so the
* peak-to-peak TIE the record reports is a real peak-to-peak and not a fragment
* of one modulation cycle. The step lands at the window midpoint.
.param w_settle='6 / w_f'
.param w_win='w_ncyc / w_f'
.param w_stop='w_settle + w_win'
.param w_stepon='w_settle + w_win / 2'
.param w_max='1 / (200 * w_f)'
.param w_frip='w_f / w_rdiv'
.csparam cs_stop={w_stop}
.csparam cs_max={w_max}

vc vctl 0 dc 'vctrl'

*----------------------------------------------------- XQ: quiet reference rail
vq nq 0 dc 'vdd_val'
eqa qa 0 nq 0 'b0'
eqb qb 0 nq 0 'b1'
eqc qc 0 nq 0 'b2'
xq vctl qa qb qc clkq nq 0 vco

*---------------------------------------------------------- XS: supply step
vsd nsd 0 dc 'vdd_val'
vst nst nsd pulse(0 'astep' 'w_stepon' 'tedge' 'tedge' 1 2)
esa sa 0 nst 0 'b0'
esb sb 0 nst 0 'b1'
esc sc 0 nst 0 'b2'
xs vctl sa sb sc clks nst 0 vco

*--------------------------------------------------------- XR: supply ripple
vrd nrd 0 dc 'vdd_val'
vrp nrp nrd sin(0 'arip' 'w_frip')
era ra 0 nrp 0 'b0'
erb rb 0 nrp 0 'b1'
erc rc 0 nrp 0 'b2'
xr vctl ra rb rc clkr nrp 0 vco

* Break the ring's metastable all-nodes-at-mid DC solution. `uic` is NOT used:
* every bias generator is solved to its operating point before t=0.
.ic v(xq.Y1)=0 v(xq.Y2)='vdd_val' v(xq.Y3)=0 v(xq.Y4)='vdd_val' v(xq.Y5)=0
.ic v(xs.Y1)=0 v(xs.Y2)='vdd_val' v(xs.Y3)=0 v(xs.Y4)='vdd_val' v(xs.Y5)=0
.ic v(xr.Y1)=0 v(xr.Y2)='vdd_val' v(xr.Y3)=0 v(xr.Y4)='vdd_val' v(xr.Y5)=0
