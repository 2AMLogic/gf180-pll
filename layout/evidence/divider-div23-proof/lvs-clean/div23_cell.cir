* Extracted by KLayout with GF180MCU LVS runset on : 21/09/2026 07:15

.SUBCKT div23_cell CKIN CKOUT MODIN MODOUT P VDD VSS
M$1 \$16 \$59 \$60 VDD pfet_03v3 L=0.28U W=2.5U AS=1.25P AD=1.25P PS=6U PD=6U
M$2 VDD \$15 \$16 VDD pfet_03v3 L=0.28U W=2.5U AS=1.25P AD=1.25P PS=6U PD=6U
M$3 VDD \$59 \$14 VDD pfet_03v3 L=0.28U W=2.5U AS=1.25P AD=1.25P PS=6U PD=6U
M$4 VDD CKIN \$59 VDD pfet_03v3 L=0.28U W=2.5U AS=1.25P AD=1.25P PS=6U PD=6U
M$5 VDD MODIN \$58 VDD pfet_03v3 L=0.28U W=2.5U AS=1.25P AD=1.25P PS=6U PD=6U
M$6 VDD \$61 MODOUT VDD pfet_03v3 L=0.28U W=2.5U AS=1.25P AD=1.25P PS=6U PD=6U
M$7 VDD \$9 \$10 VDD pfet_03v3 L=0.28U W=2.5U AS=1.25P AD=1.25P PS=6U PD=6U
M$8 VDD MODOUT \$50 VDD pfet_03v3 L=0.28U W=2.5U AS=1.25P AD=1.25P PS=6U PD=6U
M$9 \$57 \$7 \$9 VDD pfet_03v3 L=0.28U W=2.5U AS=1.25P AD=1.25P PS=6U PD=6U
M$10 VDD \$53 CKOUT VDD pfet_03v3 L=0.28U W=5U AS=2.5P AD=2.5P PS=11U PD=11U
M$11 \$8 \$7 \$56 VDD pfet_03v3 L=0.28U W=2.5U AS=1.25P AD=1.25P PS=6U PD=6U
M$12 VDD MODOUT \$17 VDD pfet_03v3 L=0.28U W=2.5U AS=1.25P AD=1.25P PS=6U PD=6U
M$13 VDD \$7 \$55 VDD pfet_03v3 L=0.28U W=2.5U AS=1.25P AD=1.25P PS=6U PD=6U
M$14 VDD CKIN \$7 VDD pfet_03v3 L=0.28U W=2.5U AS=1.25P AD=1.25P PS=6U PD=6U
M$15 \$6 \$55 \$56 VDD pfet_03v3 L=0.28U W=2.5U AS=1.25P AD=1.25P PS=6U PD=6U
M$16 VDD \$54 \$6 VDD pfet_03v3 L=0.28U W=2.5U AS=1.25P AD=1.25P PS=6U PD=6U
M$17 VDD P \$50 VDD pfet_03v3 L=0.28U W=2.5U AS=1.25P AD=1.25P PS=6U PD=6U
M$18 VDD \$60 \$15 VDD pfet_03v3 L=0.28U W=2.5U AS=1.25P AD=1.25P PS=6U PD=6U
M$19 \$17 \$14 \$61 VDD pfet_03v3 L=0.28U W=2.5U AS=1.25P AD=1.25P PS=6U PD=6U
M$20 VDD \$57 \$8 VDD pfet_03v3 L=0.28U W=2.5U AS=1.25P AD=1.25P PS=6U PD=6U
M$21 VDD \$10 \$58 VDD pfet_03v3 L=0.28U W=2.5U AS=1.25P AD=1.25P PS=6U PD=6U
M$22 VDD \$53 \$54 VDD pfet_03v3 L=0.28U W=2.5U AS=1.25P AD=1.25P PS=6U PD=6U
M$23 \$13 \$14 \$60 VDD pfet_03v3 L=0.28U W=2.5U AS=1.25P AD=1.25P PS=6U PD=6U
M$24 VDD \$50 \$54 VDD pfet_03v3 L=0.28U W=2.5U AS=1.25P AD=1.25P PS=6U PD=6U
M$25 \$15 \$59 \$61 VDD pfet_03v3 L=0.28U W=2.5U AS=1.25P AD=1.25P PS=6U PD=6U
M$26 \$53 \$55 \$9 VDD pfet_03v3 L=0.28U W=2.5U AS=1.25P AD=1.25P PS=6U PD=6U
M$27 VDD MODIN \$50 VDD pfet_03v3 L=0.28U W=2.5U AS=1.25P AD=1.25P PS=6U PD=6U
M$28 VDD \$58 \$13 VDD pfet_03v3 L=0.28U W=2.5U AS=1.25P AD=1.25P PS=6U PD=6U
M$29 VDD \$10 \$53 VDD pfet_03v3 L=0.28U W=2.5U AS=1.25P AD=1.25P PS=6U PD=6U
M$30 VDD \$56 \$57 VDD pfet_03v3 L=0.28U W=2.5U AS=1.25P AD=1.25P PS=6U PD=6U
M$31 \$50 MODIN \$51 VSS nfet_03v3 L=0.28U W=3U AS=1.5P AD=1.5P PS=7U PD=7U
M$32 \$54 \$53 \$5 VSS nfet_03v3 L=0.28U W=2U AS=1P AD=1P PS=5U PD=5U
M$33 \$51 P \$4 VSS nfet_03v3 L=0.28U W=3U AS=1.5P AD=1.5P PS=7U PD=7U
M$34 \$58 MODIN \$12 VSS nfet_03v3 L=0.28U W=2U AS=1P AD=1P PS=5U PD=5U
M$35 \$61 \$59 \$17 VSS nfet_03v3 L=0.28U W=1U AS=0.5P AD=0.5P PS=3U PD=3U
M$36 \$17 MODOUT VSS VSS nfet_03v3 L=0.28U W=1U AS=0.5P AD=0.5P PS=3U PD=3U
M$37 MODOUT \$61 VSS VSS nfet_03v3 L=0.28U W=1U AS=0.5P AD=0.5P PS=3U PD=3U
M$38 \$61 \$14 \$15 VSS nfet_03v3 L=0.28U W=1U AS=0.5P AD=0.5P PS=3U PD=3U
M$39 \$60 \$14 \$16 VSS nfet_03v3 L=0.28U W=1U AS=0.5P AD=0.5P PS=3U PD=3U
M$40 \$15 \$60 VSS VSS nfet_03v3 L=0.28U W=1U AS=0.5P AD=0.5P PS=3U PD=3U
M$41 \$60 \$59 \$13 VSS nfet_03v3 L=0.28U W=1U AS=0.5P AD=0.5P PS=3U PD=3U
M$42 \$14 \$59 VSS VSS nfet_03v3 L=0.28U W=1U AS=0.5P AD=0.5P PS=3U PD=3U
M$43 \$13 \$58 VSS VSS nfet_03v3 L=0.28U W=1U AS=0.5P AD=0.5P PS=3U PD=3U
M$44 \$12 \$10 VSS VSS nfet_03v3 L=0.28U W=2U AS=1P AD=1P PS=5U PD=5U
M$45 \$9 \$7 \$53 VSS nfet_03v3 L=0.28U W=1U AS=0.5P AD=0.5P PS=3U PD=3U
M$46 \$53 \$10 VSS VSS nfet_03v3 L=0.28U W=1U AS=0.5P AD=0.5P PS=3U PD=3U
M$47 \$9 \$55 \$57 VSS nfet_03v3 L=0.28U W=1U AS=0.5P AD=0.5P PS=3U PD=3U
M$48 \$8 \$57 VSS VSS nfet_03v3 L=0.28U W=1U AS=0.5P AD=0.5P PS=3U PD=3U
M$49 \$10 \$9 VSS VSS nfet_03v3 L=0.28U W=1U AS=0.5P AD=0.5P PS=3U PD=3U
M$50 \$57 \$56 VSS VSS nfet_03v3 L=0.28U W=1U AS=0.5P AD=0.5P PS=3U PD=3U
M$51 \$56 \$55 \$8 VSS nfet_03v3 L=0.28U W=1U AS=0.5P AD=0.5P PS=3U PD=3U
M$52 \$56 \$7 \$6 VSS nfet_03v3 L=0.28U W=1U AS=0.5P AD=0.5P PS=3U PD=3U
M$53 \$16 \$15 VSS VSS nfet_03v3 L=0.28U W=1U AS=0.5P AD=0.5P PS=3U PD=3U
M$54 \$55 \$7 VSS VSS nfet_03v3 L=0.28U W=1U AS=0.5P AD=0.5P PS=3U PD=3U
M$55 \$4 MODOUT VSS VSS nfet_03v3 L=0.28U W=3U AS=1.5P AD=1.5P PS=7U PD=7U
M$56 \$7 CKIN VSS VSS nfet_03v3 L=0.28U W=1U AS=0.5P AD=0.5P PS=3U PD=3U
M$57 \$5 \$50 VSS VSS nfet_03v3 L=0.28U W=2U AS=1P AD=1P PS=5U PD=5U
M$58 CKOUT \$53 VSS VSS nfet_03v3 L=0.28U W=2U AS=1P AD=1P PS=5U PD=5U
M$59 \$59 CKIN VSS VSS nfet_03v3 L=0.28U W=1U AS=0.5P AD=0.5P PS=3U PD=3U
M$60 \$6 \$54 VSS VSS nfet_03v3 L=0.28U W=1U AS=0.5P AD=0.5P PS=3U PD=3U
.ENDS div23_cell
